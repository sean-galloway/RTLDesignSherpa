// SPDX-License-Identifier: MIT
// SPDX-FileCopyrightText: 2024-2026 sean galloway
//
// DDR2/LPDDR2 Memory Controller CSR Register Map (PeakRDL source)
//
// Mirrors the stream component's PeakRDL methodology:
//   peakrdl regblock pumice_csr.rdl --cpuif passthrough \
//       -o ../../regs/generated/rtl/
//
// Address Space: 4 KB (12-bit paddr), 32-bit registers, little-endian.
//
// Layout matches docs/pumice_has/ch06_integration/03_csr_map.md
// plus an obs_* window at 0x1C0..0x1E3 carrying the 9-word harvest from
// docs/csr_obs_layout.md.

addrmap pumice_csr {
    name = "DDR2/LPDDR2 Memory Controller CSR";
    desc = "Configuration and observation registers for the DDR2/LPDDR2 controller";

    default regwidth = 32;
    default accesswidth = 32;
    default alignment = 4;

    //=========================================================================
    // Control and Status (0x000 – 0x00F)
    //=========================================================================

    reg {
        name = "Control Register";
        desc = "Init / power / soft-reset request bits";

        field {
            desc = "Write 1 to start init";
            sw = rw; hw = r; swmod;
        } init_start = 1'b0;

        field {
            desc = "Write 1 to force re-init even mid-sequence";
            sw = rw; hw = r; swmod;
        } init_force_restart = 1'b0;

        field {
            desc = "Reserved";
            sw = r; hw = na;
        } RSVD_3_2[3:2] = 2'h0;

        field {
            desc = "Request power-down state";
            sw = rw; hw = r;
        } pwr_req_low_power = 1'b0;

        field {
            desc = "Request DPD (LPDDR2 only)";
            sw = rw; hw = r;
        } pwr_req_dpd = 1'b0;

        field {
            desc = "Request return to ACTIVE";
            sw = rw; hw = r;
        } pwr_req_active = 1'b0;

        field {
            desc = "Request self-refresh";
            sw = rw; hw = r;
        } pwr_req_self_refresh = 1'b0;

        field {
            desc = "Reserved";
            sw = r; hw = na;
        } RSVD_30_8[30:8] = 23'h0;

        field {
            desc = "Write 1 to assert internal soft reset (self-clearing)";
            sw = rw; hw = r; swmod;
        } soft_reset = 1'b0;

    } CTRL @ 0x000;

    reg {
        name = "Status Register";
        desc = "Init / power / version status";

        field {
            desc = "Init complete";
            sw = r; hw = w;
        } init_done;

        field {
            desc = "Init error";
            sw = r; hw = w;
        } init_error;

        field {
            desc = "Reserved";
            sw = r; hw = na;
        } RSVD_3_2[3:2] = 2'h0;

        field {
            desc = "Current power-state FSM state (encoded)";
            sw = r; hw = w;
        } power_state[7:4];

        field {
            desc = "LPDDR2: PASR mask is non-zero";
            sw = r; hw = w;
        } pasr_active;

        field {
            desc = "Reserved";
            sw = r; hw = na;
        } RSVD_15_9[15:9] = 7'h0;

        field {
            desc = "Current init step number (for bring-up)";
            sw = r; hw = w;
        } init_step_dbg[23:16];

        field {
            desc = "Reserved";
            sw = r; hw = na;
        } RSVD_30_24[30:24] = 7'h0;

        field {
            desc = "Build matches expected version";
            sw = r; hw = w;
        } version_match;

    } STATUS @ 0x004;

    reg {
        name = "Status History";
        desc = "Last 8 power-state transitions, 4 bits each. Most recent in [3:0].";

        field {
            desc = "8 x 4-bit power-state history";
            sw = r; hw = w;
        } history[31:0];

    } STATUS_HISTORY @ 0x008;

    //=========================================================================
    // Timing Parameters (0x010 – 0x01F)
    //=========================================================================

    reg {
        name = "Timings: tRC / tRCD / tRP / tRAS";
        desc = "Packed timing parameters in MC cycles";

        field { sw = rw; hw = r; desc = "tRC";  } tRC[7:0]    = 8'd60;
        field { sw = rw; hw = r; desc = "tRCD"; } tRCD[15:8]  = 8'd15;
        field { sw = rw; hw = r; desc = "tRP";  } tRP[23:16]  = 8'd15;
        field { sw = rw; hw = r; desc = "tRAS"; } tRAS[31:24] = 8'd40;

    } TIMINGS_RC_RCD_RP_RAS @ 0x010;

    reg {
        name = "Timings: tRFC / tREFI";
        desc = "Refresh interval and recovery";

        // Mission-mode REF->ACT/REF recovery, MC cycles (consumed by the
        // arbiter's r_rfc_cnt; init-time refreshes use INIT_TIMING1.t_rfc_wait).
        // 16 covers DDR2 127.5ns up to ~125MHz MC clock.
        field { sw = rw; hw = r; desc = "tRFC (or tRFCab)"; } tRFC[15:0]  = 16'd16;
        field { sw = rw; hw = r; desc = "tREFI";            } tREFI[31:16] = 16'd1950;

    } TIMINGS_RFC_REFI @ 0x014;

    reg {
        name = "Timings: tRRD / tFAW / tWTR / tCCD";
        desc = "Inter-bank + bus turn-around";

        field { sw = rw; hw = r; desc = "tRRD"; } tRRD[7:0]    = 8'd6;
        field { sw = rw; hw = r; desc = "tFAW"; } tFAW[15:8]   = 8'd35;
        field { sw = rw; hw = r; desc = "tWTR"; } tWTR[23:16]  = 8'd4;
        field { sw = rw; hw = r; desc = "tCCD"; } tCCD[31:24]  = 8'd4;

    } TIMINGS_RRD_FAW_WTR_CCD @ 0x018;

    reg {
        name = "Timings: CL / CWL / tWR / tRFCpb";
        desc = "CAS latencies + write recovery + LPDDR2 per-bank tRFC";

        field { sw = rw; hw = r; desc = "CAS latency";        } CL[7:0]        = 8'd6;
        field { sw = rw; hw = r; desc = "CAS write latency";  } CWL[15:8]      = 8'd4;
        field { sw = rw; hw = r; desc = "Write recovery";     } tWR[23:16]     = 8'd15;
        field { sw = rw; hw = r; desc = "LPDDR2 per-bank tRFC"; } tRFCpb[31:24] = 8'd70;

    } TIMINGS_CL_CWL_WR @ 0x01C;

    reg {
        name = "Timings: tRTP / tRTW";
        desc = "Read-to-precharge and read-to-write turn-around (JEDEC), in MC
                cycles. Previously tRTP was hardcoded (8'd4, 'not yet in CSR map')
                and tRTW was tied to tRTP; now both are independent configs.";

        field { sw = rw; hw = r; desc = "Read to precharge"; } tRTP[7:0]  = 8'd4;
        field { sw = rw; hw = r; desc = "Read to write";     } tRTW[15:8] = 8'd6;
        field { sw = r;  hw = na; desc = "Reserved";         } RSVD[31:16] = 16'h0;

    } TIMINGS_RTP_RTW @ 0x054;

    reg {
        name = "DFI Command Phase Placement";
        desc = "Which DFI sub-phase carries the READ vs WRITE command, to match
                the PHY's rdphase/wrphase contract. For the Nexys A7 a7ddrphy
                (DDR2/CL3/nphases=2) the on-silicon ILA showed the READ burst is
                delivered aligned to rdphase=1 (wrphase=0): issuing RD on phase 0
                misaligns the returned burst (1st DFI cycle good, tail corrupt).
                Defaults 0/0 preserve the legacy all-on-phase-0 behavior. Fields
                are sliced to clog2(DFI_RATE) bits downstream; upper bits ignored
                when DFI_RATE < the field width.";

        field { sw = rw; hw = r; desc = "READ command DFI sub-phase";  } rd_phase[2:0]   = 3'd0;
        field { sw = rw; hw = r; desc = "WRITE command DFI sub-phase"; } wr_phase[6:4]   = 3'd0;
        // gear_ratio = log2(active DFI_RATE): 0=1:1, 1=1:2, 2=1:4, 3=1:8. The
        // controller datapath is BUILT for MAX_DFI_RATE (this build = 4); this
        // register selects how many of those phases are ACTIVE at runtime and
        // MUST equal the PHY's gear (nphases). On this board the a7ddrphy is
        // fixed nphases=4, so reset = 2 (1:4). Prep for a variable-gear PHY
        // (task #144/#145) -- gear is NEVER inferred, always this fixed register.
        field { sw = rw; hw = r; desc = "gear_ratio = log2(active DFI_RATE)"; } gear_ratio[8:7] = 2'd2;
        // JEDEC burst length (MR0 device beats): 4, 8, or 16. The SINGLE source
        // of truth for the burst geometry (task #146). Combined with gear_ratio
        // it selects the ACTIVE sub-DFI-word framing at runtime: when one DFI
        // word packs N = DFI_RATE/(bl>>BL_SHIFT) JEDEC bursts. The controller
        // datapath is BUILT for MAX, so a wrong value here is BAD CONFIG
        // PROGRAMMING, never a synth mismatch. Reset = 8 matches the board (DDR2
        // BL8): at nphases=4/x16 a BL8 read fills one full 128b DFI word in one
        // 8-slot PHY event (N=1, no sub-word packing) — BL4 filled only half the
        // window (stale) = the on-silicon read-fail root cause. It also carries
        // the burst length that MR0 encodes, so software programs one value.
        field { sw = rw; hw = r; desc = "JEDEC burst length (MR0 device beats): 4/8/16"; } bl[12:9] = 4'd8;
        field { sw = r;  hw = na; desc = "Reserved";                   } RSVD[31:13]      = 19'h0;

    } DFI_PHASE @ 0x060;

    reg {
        name = "PHY / DFI data timing + memory config";
        desc = "t_phy_wrlat: WRITE command -> dfi_wrdata_en (0 for a7ddrphy
                pre-pull). t_rddata_en: RD command -> dfi_rddata_en window.
                memtype: 0=DDR2, 1=LPDDR2. refresh_burst: 1..8 REFs drained per
                request. All hw-readable so they drive the controller core.";

        field { sw = rw; hw = r; desc = "t_phy_wrlat (WR cmd -> wrdata_en)"; } t_phy_wrlat[7:0]   = 8'd0;
        field { sw = rw; hw = r; desc = "t_rddata_en (RD cmd -> rddata_en)";  } t_rddata_en[15:8]  = 8'd6;
        field { sw = rw; hw = r; desc = "0=DDR2, 1=LPDDR2";                    } memtype[16:16]     = 1'b0;
        field { sw = r;  hw = na; desc = "Reserved";                           } RSVD0[19:17]      = 3'h0;
        field { sw = rw; hw = r; desc = "REFs drained per request (1..8)";     } refresh_burst[23:20] = 4'd1;
        // (deskew_lo/hi [27:24] removed: the per-beat read-deskew experiment was
        // a disproven dead-end — the board read fix was rddata_delay alignment.)
        field { sw = r;  hw = na; desc = "Reserved";                           } RSVD1[31:24]      = 8'h0;

    } PHY_TIMING @ 0x064;

    //=========================================================================
    // Mode Register Values (0x020 – 0x02F)
    //=========================================================================

    reg {
        name = "Mode Register 0";
        desc = "MR0 base value loaded during the init MRS chain (low 16 bits).
                Default 0x433 is DDR2 BL8/CL3/tWR3. The init FSM ORs in the DLL
                reset bit for the first MR0 load. Runtime-writable so software can
                retune the mode register AND sweep the value to defeat an
                arbitrary board A-lane mapping on MRS commands: write MRx.VAL then
                pulse CTRL.init_force_restart.";

        field { sw = rw; hw = r; reset = 16'h0433; desc = "MR0 value, DDR2 BL8/CL3/tWR3 default"; } VAL[15:0];
        field { sw = r;  hw = na; desc = "Reserved"; } RSVD[31:16] = 16'h0;

    } MR0 @ 0x020;

    reg {
        name = "Mode Register 1";
        desc = "MR1 value loaded during init (low 16 bits)";

        field { sw = rw; hw = r; desc = "MR1 value"; } VAL[15:0] = 16'h0;
        field { sw = r;  hw = na; desc = "Reserved"; } RSVD[31:16] = 16'h0;

    } MR1 @ 0x024;

    reg {
        name = "Mode Register 2";
        desc = "MR2 value loaded during init (low 16 bits)";

        field { sw = rw; hw = r; desc = "MR2 value"; } VAL[15:0] = 16'h0;
        field { sw = r;  hw = na; desc = "Reserved"; } RSVD[31:16] = 16'h0;

    } MR2 @ 0x028;

    reg {
        name = "Mode Register 3";
        desc = "MR3 value loaded during init (low 16 bits)";

        field { sw = rw; hw = r; desc = "MR3 value"; } VAL[15:0] = 16'h0;
        field { sw = r;  hw = na; desc = "Reserved"; } RSVD[31:16] = 16'h0;

    } MR3 @ 0x02C;

    //=========================================================================
    // LPDDR2-Specific (0x030 – 0x03F)
    //=========================================================================

    reg {
        name = "PASR Bank Mask Rank 0";
        desc = "LPDDR2 PASR per-bank mask for rank 0 (MR16). Bit N=1 masks bank N.";

        field { sw = rw; hw = r; desc = "Bank mask"; } pasr_banks[7:0] = 8'h0;
        field { sw = r;  hw = na; desc = "Reserved"; } RSVD[31:8] = 24'h0;

    } PASR_BANK_MASK_RANK0 @ 0x030;

    reg {
        name = "PASR Segment Mask Rank 0";
        desc = "LPDDR2 PASR segment mask for rank 0";

        field { sw = rw; hw = r; desc = "Segment mask"; } pasr_segs[7:0] = 8'h0;
        field { sw = r;  hw = na; desc = "Reserved"; } RSVD[31:8] = 24'h0;

    } PASR_SEG_MASK_RANK0 @ 0x034;

    reg {
        name = "Temperature Derate Rank 0";
        desc = "LPDDR2 MR4 temperature class for rank 0";

        field {
            sw = r; hw = w;
            desc = "00 = nominal, 01 = 2x refresh, 10 = 4x refresh";
        } temp_class[1:0];

        field { sw = r; hw = na; desc = "Reserved"; } RSVD[31:2] = 30'h0;

    } TEMP_DERATE_RANK0 @ 0x038;

    //=========================================================================
    // Scheduler / Refresh / Page / Addr / Init Tuning (0x040 – 0x05F)
    //=========================================================================

    reg {
        name = "Scheduler Tuning";
        desc = "Runtime scheduler knobs (effective at next quiet point)";

        field {
            sw = rw; hw = r;
            desc = "Active lookahead window (0..LOOKAHEAD_DEPTH_MAX). 0 disables.";
        } lookahead_active[3:0] = 4'h0;

        field {
            sw = rw; hw = r;
            desc = "1 = force first-ready FIFO (disable row-hit reordering)";
        } force_inorder = 1'b0;

        field {
            sw = r; hw = na;
            desc = "Reserved (was happy_enable; the HAPPY predictor is retired -- adaptive paging is PAGE_POLICY_CFG.policy_mode)";
        } RSVD_5 = 1'b0;

        field { sw = r; hw = na; desc = "Reserved"; } RSVD_7_6[7:6] = 2'h0;

        field {
            sw = rw; hw = r;
            desc = "Runtime AGE_MAX override (0 = use build-time default)";
        } age_max_runtime[15:8] = 8'h0;

        field {
            sw = rw; hw = r;
            desc = "Backpressure-assertion threshold for txn queue";
        } txn_queue_high_water[23:16] = 8'h0;

        field {
            sw = r; hw = w;
            desc = "Echo of build-time LOOKAHEAD_DEPTH_MAX";
        } lookahead_max_obs[27:24];

        field { sw = r; hw = na; desc = "Reserved"; } RSVD_31_28[31:28] = 4'h0;

    } SCHED_TUNING @ 0x040;

    // 0x044 (was PAGE_PRED_TUNING) -- retired with the HAPPY predictor. The
    // adaptive-paging knobs live in PAGE_POLICY_CFG / PAGE_TIMEOUT_CFG /
    // PAGE_ADAPT_CFG. Address intentionally left unmapped.

    reg {
        name = "Refresh Tuning";
        desc = "Refresh policy + ZQCS interval";

        field {
            sw = rw; hw = r;
            desc = "00=build-time, 01=RR, 10=OLDEST_FIRST, 11=DARP";
        } refpb_policy_or[1:0] = 2'h0;

        field {
            sw = rw; hw = r;
            desc = "00=build-time, 01=OPEN, 10=CLOSE, 11=reserved (was HYBRID; maps to build default)";
        } page_policy_or[3:2] = 2'h0;

        field {
            sw = rw; hw = r;
            desc = "Active refresh deferral count (1..REFRESH_DEFER_MAX)";
        } refresh_defer_active[7:4] = 4'h1;

        field { sw = r; hw = na; desc = "Reserved"; } RSVD_15_8[15:8] = 8'h0;

        field {
            sw = rw; hw = r;
            desc = "Periodic ZQCS interval in Hz (0 = disabled)";
        } zqcs_freq_hz[31:16] = 16'd1;

    } REFRESH_TUNING @ 0x048;

    reg {
        name = "Address Map";
        desc = "AXI-address -> {rank,row,bank,col} mapping. bank_lsb is where the
                bank field sits in the (byte-offset-stripped) word address; the
                column fills below (col_lo) and above (col_hi) it, row/rank stack
                above. ROW_MAJOR / BANK_INTERLEAVE / XOR_HASH are just settings of
                this register (no separate scheme selector). See addr_mapper.sv.";

        // Bank LSB = # of low column bits kept BELOW the bank field. A DRAM burst
        // lives in those low bits, so it stays within one bank.
        //   = COL_WIDTH          -> bank above whole column  = ROW_MAJOR
        //   = log2(BL/DFI_RATE)  -> minimal col_lo           = max BANK_INTERLEAVE
        //   in between           -> partial interleave (burst locality preserved)
        // Constraint: log2(BL/DFI_RATE) <= bank_lsb <= COL_WIDTH (RTL clamps).
        field {
            sw = rw; hw = r;
            desc = "Bank field LSB in the word address (=COL_WIDTH -> ROW_MAJOR)";
        } bank_lsb[4:0] = 5'd10;

        field { sw = r; hw = na; desc = "Reserved"; } RSVD_7_5[7:5] = 3'h0;

        field {
            sw = rw; hw = r;
            desc = "Enable bank XOR-hash: bank ^= fold(row) ^ hash_seed";
        } hash_en[8:8] = 1'b0;

        field { sw = r; hw = na; desc = "Reserved"; } RSVD_15_9[15:9] = 7'h0;

        field {
            sw = rw; hw = r;
            desc = "XOR-hash seed (bank ^= fold(row) ^ seed[BW-1:0])";
        } hash_seed[23:16] = 8'h00;

        field { sw = r; hw = na; desc = "Reserved"; } RSVD_31_24[31:24] = 8'h0;

    } ADDR_MAP @ 0x04C;

    reg {
        name = "Init Tuning";
        desc = "ZQ retries + per-step init timeout";

        field { sw = rw; hw = r; desc = "ZQ retries (1..8)";     } zq_retries[3:0]     = 4'd3;
        field { sw = r;  hw = na; desc = "Reserved";              } RSVD_7_4[7:4] = 4'h0;
        field { sw = rw; hw = r; desc = "Init timeout ms (1..255)"; } init_timeout_ms[15:8] = 8'd10;
        field { sw = r;  hw = na; desc = "Reserved";              } RSVD_31_16[31:16] = 16'h0;

    } INIT_TUNING @ 0x050;

    reg {
        name = "Init Timing 0: tINIT / tDLLK";
        desc = "JEDEC init-sequence waits (MC cycles): CKE/tINIT settle and DLL
                lock. Previously hardcoded in init_sequencer.";

        field { sw = rw; hw = r; desc = "CKE/tINIT settle"; } t_init_wait[15:0]  = 16'd512;
        field { sw = rw; hw = r; desc = "DLL lock (tDLLK)"; } t_dll_wait[31:16]  = 16'd256;

    } INIT_TIMING0 @ 0x058;

    reg {
        name = "Init Timing 1: tMRD / tRP / tRFC (init)";
        desc = "JEDEC init-sequence waits (MC cycles): post-MRS (tMRD),
                post-precharge (tRP), post-refresh (tRFC). Previously hardcoded.";

        field { sw = rw; hw = r; desc = "tMRD (post mode-reg)"; } t_mrd_wait[7:0]  = 8'd8;
        field { sw = rw; hw = r; desc = "tRP (post precharge)"; } t_rp_wait[15:8]  = 8'd8;
        field { sw = rw; hw = r; desc = "tRFC (post refresh)";  } t_rfc_wait[23:16]= 8'd16;
        field { sw = r;  hw = na; desc = "Reserved";            } RSVD[31:24] = 8'h0;

    } INIT_TIMING1 @ 0x05C;

    //=========================================================================
    // Per-Bank Observation (0x080 – 0x09F) — NUM_BANKS=8, rank 0
    //=========================================================================

    regfile {
        name = "Per-Bank Row Hit Observation";
        desc = "Rolling row-hit count per bank. Reset on read or soft_reset.";

        reg {
            field {
                sw = rw; hw = w; onread = rclr;
                desc = "Row-hit count";
            } VAL[31:0];
        } ROW_HIT @ 0x0;

    } OBS_ROW_HIT[8] @ 0x080 += 0x4;

    regfile {
        name = "Per-Bank Refresh Latency Observation";
        desc = "Average refresh blocking time per bank";

        reg {
            field { sw = r; hw = w; desc = "Refresh-blocking cycles"; } VAL[31:0];
        } REF_LAT @ 0x0;

    } OBS_REF_LATENCY[8] @ 0x0C0 += 0x4;

    //=========================================================================
    // System Observation (0x100 – 0x1FF)
    //=========================================================================

    reg {
        desc = "Max queue depth observed";
        field { sw = r; hw = w; desc = "Max depth"; } VAL[31:0];
    } OBS_TXN_QUEUE_DEPTH_MAX @ 0x100;

    reg {
        desc = "Time-averaged queue depth";
        field { sw = r; hw = w; desc = "Avg depth"; } VAL[31:0];
    } OBS_TXN_QUEUE_DEPTH_AVG @ 0x104;

    reg {
        desc = "Max refresh_pending observed";
        field { sw = r; hw = w; desc = "Max pending"; } VAL[31:0];
    } OBS_REFRESH_PENDING_MAX @ 0x108;

    reg {
        desc = "Refresh-deferral histogram bin 0";
        field { sw = r; hw = w; desc = "Bin 0 count"; } VAL[31:0];
    } OBS_REFRESH_DEFER_HIST_0 @ 0x10C;

    reg {
        desc = "Refresh-deferral histogram bin 1";
        field { sw = r; hw = w; desc = "Bin 1 count"; } VAL[31:0];
    } OBS_REFRESH_DEFER_HIST_1 @ 0x110;

    reg {
        desc = "Refresh-deferral histogram bin 2";
        field { sw = r; hw = w; desc = "Bin 2 count"; } VAL[31:0];
    } OBS_REFRESH_DEFER_HIST_2 @ 0x114;

    reg {
        desc = "Refresh-deferral histogram bin 3";
        field { sw = r; hw = w; desc = "Bin 3 count"; } VAL[31:0];
    } OBS_REFRESH_DEFER_HIST_3 @ 0x118;

    // 0x120 (was OBS_PAGE_PRED_ACCURACY) -- retired with the HAPPY predictor;
    // page-outcome telemetry is PAGE_STATS_{HIT,MISS,EMPTY}.

    reg {
        desc = "Avg AXI read latency (cycles)";
        field { sw = r; hw = w; desc = "Avg cycles"; } VAL[31:0];
    } OBS_AXI_R_LATENCY_AVG @ 0x130;

    reg {
        desc = "99th-pct AXI read latency";
        field { sw = r; hw = w; desc = "P99 cycles"; } VAL[31:0];
    } OBS_AXI_R_LATENCY_P99 @ 0x134;

    reg {
        desc = "Avg AXI write latency";
        field { sw = r; hw = w; desc = "Avg cycles"; } VAL[31:0];
    } OBS_AXI_W_LATENCY_AVG @ 0x138;

    //=========================================================================
    // obs_* harvest words (0x1C0 – 0x1E3) — see docs/csr_obs_layout.md.
    // 9 RO 32-bit words carrying the packed obs_* signals from
    // command_scheduler_macro (words 0..6) + axi_frontend_macro (words 7..8).
    //=========================================================================

    regfile {
        name = "Observation Word Harvest";
        desc = "Packed obs_* signals from FUB internals (see csr_obs_layout.md)";

        reg {
            field { sw = r; hw = w; desc = "Obs word"; } VAL[31:0];
        } WORD @ 0x0;

    } OBS_WORDS[9] @ 0x1C0 += 0x4;

    //=========================================================================
    // Advanced-mode select CSRs (0x068 – 0x07C, 0x140 – 0x15C) — PUMICE-006
    //
    // The characterization surface from design-requirements.md "Advanced
    // modes": every mechanism is a config-bit-selectable MODE, added serially
    // behind its own enable, reset = the build default (bit-identical to the
    // pre-PUMICE-006 controller). These registers land FIRST, before any
    // consuming logic, so the software surface is stable while the modes
    // arrive one red->green step at a time. Encodings with value 0 always
    // mean "build default / current behavior".
    //
    // The legacy knobs (SCHED_TUNING.force_inorder / lookahead,
    // REFRESH_TUNING.page_policy_or / refpb_policy_or / refresh_defer_active)
    // remain live and authoritative until the corresponding mode consumes its
    // NEW field here; each mode's landing commit retires or aliases the old
    // knob explicitly. Until then hardware ignores these fields.
    //=========================================================================

    reg {
        name = "Scheduler Policy";
        desc = "Axis 1 (Rixner FR-FCFS variants). All fields 0 = build default.";

        field {
            sw = rw; hw = r;
            desc = "0=build default, 1=in_order, 2=fr_fcfs, 3=age_threshold";
        } order_mode[1:0] = 2'h0;

        field {
            sw = rw; hw = r;
            desc = "Priority sub-policy: 0=default, 1=none, 2=load_over_store, 3=age_boost";
        } prio_sub[3:2] = 2'h0;

        field {
            sw = rw; hw = r;
            desc = "Row-arbiter select: 0=default(oldest), 1=most_pending, 2=fewest_pending";
        } row_sel[5:4] = 2'h0;

        field {
            sw = rw; hw = r;
            desc = "Column-arbiter select: 0=default(oldest), 1=most_pending, 2=fewest_pending";
        } col_sel[7:6] = 2'h0;

        field {
            sw = rw; hw = r;
            desc = "Address-arbiter class preference: 0=default, 1=column_first, 2=row_first, 3=precharge_first";
        } access_pref[9:8] = 2'h0;

        field {
            sw = rw; hw = r;
            desc = "1 = fuse auto-precharge into the last column op of a row";
        } auto_precharge_en[10:10] = 1'b0;

        field {
            sw = rw; hw = r;
            desc = "1 = factor AxQOS into the pick (highest ready first, age tie-break)";
        } qos_en[11:11] = 1'b0;

        field { sw = r; hw = na; desc = "Reserved"; } RSVD_15_12[15:12] = 4'h0;

        field {
            sw = rw; hw = r;
            desc = "age_threshold mode: age (MC cycles/16) above which a reference is boosted";
        } age_thresh[23:16] = 8'h0;

        field { sw = r; hw = na; desc = "Reserved"; } RSVD_31_24[31:24] = 8'h0;

    } SCHED_POLICY @ 0x068;

    reg {
        name = "Scheduler Write Watermarks";
        desc = "Write-batching drain hysteresis. 0/0 = build default (no batching).";

        field {
            sw = rw; hw = r;
            desc = "Start back-to-back write drain when the write buffer crosses this";
        } wr_high_wm[7:0] = 8'h0;

        field {
            sw = rw; hw = r;
            desc = "Stop the drain when occupancy falls to this";
        } wr_low_wm[15:8] = 8'h0;

        field { sw = r; hw = na; desc = "Reserved"; } RSVD[31:16] = 16'h0;

    } SCHED_WR_WM @ 0x06C;

    reg {
        name = "Page Policy Config";
        desc = "Axis 2 mode select + adapt_access counter shape. 0 = build default.";

        field {
            sw = rw; hw = r;
            desc = "0=build default, 1=static_open, 2=static_close, 3=fixed_open, 4=adapt_time, 5=adapt_access, 6=rbl_static, 7=rbl_dyn";
        } policy_mode[2:0] = 3'h0;

        field {
            sw = rw; hw = r;
            desc = "0 = per-bank decision state, 1 = global";
        } policy_scope[3:3] = 1'b0;

        field {
            sw = rw; hw = r;
            desc = "adapt_access counter width select (0=2-bit)";
        } ctr_width[5:4] = 2'h0;

        field {
            sw = rw; hw = r;
            desc = "adapt_access: counter value at/above which the row is CLOSED";
        } ctr_open_max[9:6] = 4'h0;

        field {
            sw = rw; hw = r;
            desc = "adapt_access: counter init value";
        } ctr_init[13:10] = 4'h0;

        field { sw = r; hw = na; desc = "Reserved"; } RSVD[31:14] = 18'h0;

    } PAGE_POLICY_CFG @ 0x070;

    reg {
        name = "Page Timeout Config";
        desc = "fixed_open / adapt_time timeout register bounds (MC cycles).";

        field { sw = rw; hw = r; desc = "TR init (fixed_open uses this alone; ~tRC)"; } tr_init[7:0]  = 8'h0;
        field { sw = rw; hw = r; desc = "adapt_time TR lower clamp";                  } tr_min[15:8]  = 8'h0;
        field { sw = rw; hw = r; desc = "adapt_time TR upper clamp";                  } tr_max[23:16] = 8'h0;
        field { sw = rw; hw = r; desc = "adapt_time TR adjustment step";              } tr_step[31:24] = 8'h0;

    } PAGE_TIMEOUT_CFG @ 0x074;

    reg {
        name = "Page Adaptive Config";
        desc = "adapt_time (Happy adaptive-timeout) mistake-counter thresholds.";

        field { sw = rw; hw = r; desc = "MC high threshold (TR += step above)";  } mc_high_thr[3:0]  = 4'h0;
        field { sw = rw; hw = r; desc = "MC low threshold (TR -= step below)";   } mc_low_thr[7:4]   = 4'h0;
        field { sw = rw; hw = r; desc = "MC init value";                          } mc_init[11:8]     = 4'h0;
        field { sw = r; hw = na; desc = "Reserved";                               } RSVD[15:12] = 4'h0;
        field { sw = rw; hw = r; desc = "Cycles between MC evaluations";          } check_interval[31:16] = 16'h0;

    } PAGE_ADAPT_CFG @ 0x078;

    reg {
        name = "Page RBL Config";
        desc = "RBLA/Yoon miss-counter table shape. rbl_dyn hill-climb weights land with that mode.";

        field { sw = rw; hw = r; desc = "Miss count above which a row is low-locality (auto-precharge)"; } miss_thresh[7:0] = 8'h0;
        field { sw = rw; hw = r; desc = "log2 table ways";                        } ways[9:8]   = 2'h0;
        field { sw = rw; hw = r; desc = "log2 table sets";                        } sets[13:10] = 4'h0;
        field { sw = r; hw = na; desc = "Reserved";                               } RSVD[15:14] = 2'h0;
        field { sw = rw; hw = r; desc = "Epoch length: counters reset every N cycles (0=never)"; } reset_interval[31:16] = 16'h0;

    } PAGE_RBL_CFG @ 0x07C;

    reg {
        name = "Refresh Mode Control";
        desc = "Axis 3 mode + JEDEC +-8 credit limits. tREFI/tRFCab live in TIMINGS_RFC_REFI (not duplicated).";

        field {
            sw = rw; hw = r;
            desc = "0=build default (REFab), 1=REFab, 2=REFpb round-robin (LPDDR2)";
        } mode[1:0] = 2'h0;

        field { sw = r; hw = na; desc = "Reserved"; } RSVD_3_2[3:2] = 2'h0;

        field {
            sw = rw; hw = r;
            desc = "Max refreshes postponed under demand (0..8; 0 = strict)";
        } postpone_limit[7:4] = 4'h0;

        field {
            sw = rw; hw = r;
            desc = "Max refreshes pulled in on idle (0..8; 0 = strict)";
        } pullin_limit[11:8] = 4'h0;

        field {
            sw = r; hw = w;
            desc = "Capability strap: 1 = the DRAM supports per-bank refresh";
        } perbank_supported[12:12];

        field { sw = r; hw = na; desc = "Reserved"; } RSVD_31_13[31:13] = 19'h0;

    } REF_CTRL @ 0x140;

    reg {
        name = "Per-Bank Refresh Timing";
        desc = "REFpb intervals (MC cycles). All-bank tREFI/tRFCab stay in TIMINGS_RFC_REFI.";

        field { sw = rw; hw = r; desc = "tREFIpb (~tREFI/8; 0 = derive from tREFI)"; } trefi_pb[15:0] = 16'h0;
        field { sw = rw; hw = r; desc = "tRFCpb recovery";                            } trfc_pb[23:16] = 8'h0;
        field { sw = r; hw = na; desc = "Reserved";                                   } RSVD[31:24] = 8'h0;

    } REF_TIMING_PB @ 0x144;

    //-------------------------------------------------------------------------
    // Mode telemetry (read-only). Complements the existing OBS_* set:
    // OBS_ROW_HIT[8] (per-bank hits) and OBS_REFRESH_DEFER_HIST_0..3 already
    // exist; these add the GLOBAL page-outcome and command-class counters the
    // in-system sweeps compare across modes. Per-bank TR readback lands with
    // adapt_time. All are tied to 0 until the counting logic lands.
    //-------------------------------------------------------------------------

    reg {
        name = "Page Stats: Hits";
        field { sw = r; hw = w; desc = "Column ops issued to an already-open row"; } count[31:0];
    } PAGE_STATS_HIT @ 0x148;

    reg {
        name = "Page Stats: Misses";
        field { sw = r; hw = w; desc = "Column ops that required PRE+ACT (conflict)"; } count[31:0];
    } PAGE_STATS_MISS @ 0x14C;

    reg {
        name = "Page Stats: Empties";
        field { sw = r; hw = w; desc = "Column ops that required ACT only (bank closed)"; } count[31:0];
    } PAGE_STATS_EMPTY @ 0x150;

    reg {
        name = "Sched Stats: Activates";
        field { sw = r; hw = w; desc = "ACT commands issued"; } count[31:0];
    } SCHED_STATS_ACT @ 0x154;

    reg {
        name = "Sched Stats: Precharges";
        field { sw = r; hw = w; desc = "PRE + PREA commands issued"; } count[31:0];
    } SCHED_STATS_PRE @ 0x158;

    reg {
        name = "Refresh Stats: Refreshes";
        field { sw = r; hw = w; desc = "REFab + REFpb commands issued"; } count[31:0];
    } REF_STATS_REF @ 0x15C;

    //=========================================================================
    // Module Identification (0xFF0 – 0xFFC)
    //=========================================================================

    reg {
        name = "Module ID";

        field { sw = r; hw = na; desc = "Build version";          } version[7:0]    = 8'h01;
        field { sw = r; hw = na; desc = "0=DDR2, 1=LPDDR2";        } memtype[15:8]   = 8'h00;
        field { sw = r; hw = na; desc = "Gear ratio (1, 2, or 4)"; } n_phases[23:16] = 8'h02;
        field { sw = r; hw = na; desc = "Fixed 0xD2";              } module_id[31:24] = 8'hD2;

    } ID @ 0xFF0;

    reg {
        name = "Build Hash";
        field { sw = r; hw = na; desc = "Build hash word"; } VAL[31:0] = 32'h0;
    } BUILD @ 0xFF4;

};
