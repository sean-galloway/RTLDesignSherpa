// SPDX-License-Identifier: MIT
// SPDX-FileCopyrightText: 2026 sean galloway
//
// Configuration for axi4_dma_observer -- the inline performance-observation
// block on the STREAM datapath.
//
// WHY THIS EXISTS: the observer took 31 cfg_* ports and the harness tied 18 of
// them off to constants. That is the same shape dma_slave_monitors had before
// it grew its own APB: a block whose configuration lives in whoever happens to
// instantiate it, so every harness must know its internals and no host can
// change anything at runtime. With the config local, the harness is reduced to
// instantiation and one bridge slave, which is what lets a SINGLE harness
// source serve both the monitor and the performance builds.
//
// Three protocol groups, because the observer watches three kinds of traffic:
//   AXI   -- the DMA datapath itself
//   AXIS  -- the stream side
//   CORE  -- scheduler / descriptor-engine events
// Each group has the same shape as the in-core monitors' MON regfile
// (stream_mon_regs.rdl) and the slave monitors' (slvmon_regs.rdl), so a host
// that can drive one can drive all three without learning a new idiom.
//
// Mask polarity, stated once because the RDL got it backwards elsewhere:
// PKT_MASK bit[type] = 1 means DROP that packet type (RTL:
// pkt_drop = cfg_axi_pkt_mask[pkt_type]). The per-class masks are indexed by
// event_code[3:0], so they are 16 bits -- not 8, which was the defect that
// made event codes >= 8 unmaskable on the in-core monitors.
//
// Defaults reproduce the harness's previous tie-offs, so this is behaviour
// neutral until a host writes.

regfile obs_regs {
    name = "DMA observer configuration";
    desc = "Runtime config for the inline performance-observation block";

    //-------------------------------------------------------------------------
    // AXI protocol group -- the DMA datapath
    //-------------------------------------------------------------------------
    reg { name = "AXI packet mask"; desc = "bit[type]=1 drops that packet type; ERR_SELECT routes err-FIFO vs bulk";
          field { sw=rw; hw=r; } PKT_MASK[15:0]    = 16'h0000;
          field { sw=rw; hw=r; } ERR_SELECT[31:16] = 16'h0000; } AXI_PKT_MASK @ 0x000;
    reg { name = "AXI mask1"; desc = "Per-event-code drop masks, indexed by event_code[3:0]";
          field { sw=rw; hw=r; } ERROR_MASK[15:0]    = 16'h0000;
          field { sw=rw; hw=r; } TIMEOUT_MASK[31:16] = 16'h0000; } AXI_MASK1 @ 0x004;
    reg { name = "AXI mask2"; desc = "Per-event-code drop masks";
          field { sw=rw; hw=r; } COMPL_MASK[15:0]   = 16'h0000;
          field { sw=rw; hw=r; } THRESH_MASK[31:16] = 16'h0000; } AXI_MASK2 @ 0x008;
    reg { name = "AXI mask3"; desc = "Per-event-code drop masks";
          field { sw=rw; hw=r; } PERF_MASK[15:0]  = 16'h0000;
          field { sw=rw; hw=r; } ADDR_MASK[31:16] = 16'h0000; } AXI_MASK3 @ 0x00C;
    reg { name = "AXI mask4"; desc = "Per-event-code drop masks";
          field { sw=rw; hw=r; } DEBUG_MASK[15:0] = 16'h0000;
          field { sw=r;  hw=na; } RSVD[31:16] = 16'h0; } AXI_MASK4 @ 0x010;

    //-------------------------------------------------------------------------
    // AXIS protocol group -- the stream side
    //-------------------------------------------------------------------------
    reg { name = "AXIS packet mask"; desc = "bit[type]=1 drops that packet type";
          field { sw=rw; hw=r; } PKT_MASK[15:0]    = 16'h0000;
          field { sw=rw; hw=r; } ERR_SELECT[31:16] = 16'h0000; } AXIS_PKT_MASK @ 0x020;
    reg { name = "AXIS mask1"; desc = "Per-event-code drop masks";
          field { sw=rw; hw=r; } ERROR_MASK[15:0]    = 16'h0000;
          field { sw=rw; hw=r; } TIMEOUT_MASK[31:16] = 16'h0000; } AXIS_MASK1 @ 0x024;
    reg { name = "AXIS mask2"; desc = "Per-event-code drop masks";
          field { sw=rw; hw=r; } COMPL_MASK[15:0]    = 16'h0000;
          field { sw=rw; hw=r; } CHANNEL_MASK[31:16] = 16'h0000; } AXIS_MASK2 @ 0x028;
    reg { name = "AXIS mask3"; desc = "Per-event-code drop masks";
          field { sw=rw; hw=r; } CREDIT_MASK[15:0]  = 16'h0000;
          field { sw=rw; hw=r; } STREAM_MASK[31:16] = 16'h0000; } AXIS_MASK3 @ 0x02C;

    //-------------------------------------------------------------------------
    // CORE protocol group -- scheduler / descriptor-engine events
    //-------------------------------------------------------------------------
    reg { name = "CORE packet mask"; desc = "bit[type]=1 drops that packet type";
          field { sw=rw; hw=r; } PKT_MASK[15:0]    = 16'h0000;
          field { sw=rw; hw=r; } ERR_SELECT[31:16] = 16'h0000; } CORE_PKT_MASK @ 0x040;
    reg { name = "CORE mask1"; desc = "Per-event-code drop masks";
          field { sw=rw; hw=r; } ERROR_MASK[15:0]    = 16'h0000;
          field { sw=rw; hw=r; } TIMEOUT_MASK[31:16] = 16'h0000; } CORE_MASK1 @ 0x044;
    reg { name = "CORE mask2"; desc = "Per-event-code drop masks";
          field { sw=rw; hw=r; } COMPL_MASK[15:0]   = 16'h0000;
          field { sw=rw; hw=r; } THRESH_MASK[31:16] = 16'h0000; } CORE_MASK2 @ 0x048;
    reg { name = "CORE mask3"; desc = "Per-event-code drop masks";
          field { sw=rw; hw=r; } PERF_MASK[15:0]  = 16'h0000;
          field { sw=rw; hw=r; } DEBUG_MASK[31:16] = 16'h0000; } CORE_MASK3 @ 0x04C;

    //-------------------------------------------------------------------------
    // Group-level controls
    //-------------------------------------------------------------------------
    reg { name = "Observer control"; desc = "Monbus group drain + compression";
          field { desc = "Bulk-write flush watermark"; sw=rw; hw=r; } FLUSH_WATERMARK[15:0] = 16'h0010;
          field { desc = "1 = compress the monbus write stream. The tally reassembles RAW 3-beat records, so leave 0 unless the consumer decompresses.";
                  sw=rw; hw=r; } COMPRESS_EN[16:16] = 1'b0;
          field { desc = "counter_freq_invariant LUT index, used only when FREQ_SEL_OVR=1. The LUT is 60+5*i MHz, so 4=80, 6=90, 8=100, 12=120.";
                  sw=rw; hw=r; } FREQ_SEL[20:17] = 4'h0;
          field { desc = "0 = use the build-time index derived from ACLK_MHZ (correct at reset for any build frequency); 1 = use FREQ_SEL instead. Exists so the reset value cannot silently disagree with the actual clock.";
                  sw=rw; hw=r; } FREQ_SEL_OVR[21:21] = 1'b0;
          field { sw=r; hw=na; } RSVD[31:22] = 10'h0; } OBS_CTRL @ 0x060;

    reg { name = "Observer window base";  desc = "Monbus bulk-write window low bound";
          field { sw=rw; hw=r; } VALUE[31:0] = 32'h0004_0000; } OBS_BASE_ADDR  @ 0x064;
    reg { name = "Observer window limit"; desc = "Monbus bulk-write window high bound";
          field { sw=rw; hw=r; } VALUE[31:0] = 32'h0007_FFFF; } OBS_LIMIT_ADDR @ 0x068;

    //-------------------------------------------------------------------------
    // Telemetry readback (0x070+)
    //
    // The meters, latency histograms and perf counters are PER TAP and PER
    // CHANNEL, so exposing them flat would be hundreds of registers -- and
    // exposing them as PORTS (what this block used to do) cost 70 tie-offs per
    // instance, every one of them a silent break if forgotten. Indexed
    // select/data instead, the same shape stream_regs uses for HIST_SEL /
    // HIST_DATA.
    //
    // Write OBS_STAT_SEL, then read OBS_STAT_DATA. The selection is registered
    // in hardware, so the read returns the addressed counter with no side
    // effects and re-reading is safe.
    //
    // IDENTICAL IN BOTH OBSERVERS. The master and slave observers differ only
    // in which monitor flavour they instantiate; their register map is the
    // same file, so one host decoder and one regmap serve both.
    //-------------------------------------------------------------------------
    reg { name = "Telemetry select"; desc = "Addresses one telemetry counter for OBS_STAT_DATA";
          field { desc = "Tap index (0..NUM_RD_PORTS-1 for read metrics, 0..NUM_WR_PORTS-1 for write)";
                  sw=rw; hw=r; } TAP[7:0] = 8'h00;
          field { desc = "Channel index within the tap; ignored for aggregate metrics";
                  sw=rw; hw=r; } CHANNEL[15:8] = 8'h00;
          field { desc = "Metric id. AGGREGATE (per tap): 0=productive, 1=backpressure, 2=starvation, 3=idle. PER CHANNEL (uses CHANNEL): 4=productive, 5=backpressure, 6=starvation, 7=idle, 8=overflow. HISTOGRAM: 9=bin (NOT YET READABLE - the bin is chosen by the i_hist_bin input port, so BIN here is accepted and ignored and this reads 0), 10=total. Any other value reads 0.";
                  sw=rw; hw=r; } METRIC[23:16] = 8'h00;
          field { desc = "0 = read-side metric, 1 = write-side"; sw=rw; hw=r; } IS_WRITE[24:24] = 1'b0;
          field { desc = "Histogram bin index, used when METRIC=9"; sw=rw; hw=r; } BIN[30:25] = 6'h00;
          field { desc = "Which latency metric the histogram reports (e.g. AR->firstR vs AR->RLAST). SEPARATE from IS_WRITE, which selects the read- or write-side array -- conflating them makes half the histogram unreachable.";
                  sw=rw; hw=r; } HIST_METRIC[31:31] = 1'b0;
        } OBS_STAT_SEL @ 0x070;

    reg { name = "Telemetry data"; desc = "The counter addressed by OBS_STAT_SEL. Reads as 0 for a metric this instance does not build (meters/histograms are parameter-gated).";
          field { sw=r; hw=w; } VALUE[31:0] = 32'h0; } OBS_STAT_DATA @ 0x074;

    reg { name = "Monbus FIFO status"; desc = "Group err/write FIFO occupancy and full flags";
          field { sw=r; hw=w; } ERR_COUNT[15:0]   = 16'h0;
          field { sw=r; hw=w; } WRITE_COUNT[30:16] = 15'h0;
          field { desc = "Either FIFO full"; sw=r; hw=w; } ANY_FULL[31:31] = 1'b0;
        } OBS_FIFO_STAT @ 0x078;

    reg { name = "Observer sticky status"; desc = "Sticky flags. A dropped sample or a blocked tap means the numbers above are INCOMPLETE, so it has to be readable alongside them.";
          field { desc = "A latency-histogram timestamp was dropped"; sw=r; hw=w; } HIST_SAMPLE_LOST[0:0] = 1'b0;
          field { desc = "Any tap asserted block_ready (its table filled, so it stopped tracking)"; sw=r; hw=w; } TAP_BLOCKED[1:1] = 1'b0;
          field { sw=r; hw=na; } RSVD[31:2] = 30'h0; } OBS_STICKY @ 0x07C;

    reg { name = "Compressor stats"; desc = "monbus_compressor tier hits and CAM misses";
          field { sw=r; hw=w; } TIER1[15:0] = 16'h0;
          field { sw=r; hw=w; } TIER0[31:16] = 16'h0; } OBS_COMP_STAT0 @ 0x080;
    reg { name = "Compressor stats 2"; desc = "CAM miss and overflow counters";
          field { sw=r; hw=w; } CAM_MISS[15:0] = 16'h0;
          field { sw=r; hw=w; } OVERFLOW[31:16] = 16'h0; } OBS_COMP_STAT1 @ 0x084;

    //-------------------------------------------------------------------------
    // Monitor tap configuration (0x090+)
    //
    // These were the LAST tie-offs: 26 cfg_* inputs on the rd/wr monitors,
    // hardcoded at the instantiation in both observers and reachable from
    // nowhere. That is what made the observers untestable -- completions were
    // enabled, the perf cone was not, and no host could change either. Every
    // default below is the constant it replaces, so this stays behaviour
    // neutral until a host writes.
    //
    // NOTE the two-gate structure, because it is not obvious and it cost a
    // full debug cycle: these are RUNTIME enables, and they only do anything
    // if the corresponding cone was BUILT (TAP_ENABLE_*_LOGIC, a parameter --
    // it decides whether the logic exists in silicon, so it cannot be a
    // register without paying the area unconditionally). Read OBS_CAPS0 to
    // find out what this instance actually has. An enable whose cone is
    // absent reads back as written and does nothing.
    //-------------------------------------------------------------------------
    reg { name = "Monitor tap control"; desc = "Per-cone runtime enables for the rd/wr monitors. Gated by the build-time cones in OBS_CAPS0.";
          field { desc = "Emit ERROR packets";     sw=rw; hw=r; } ERROR_EN[0:0]      = 1'b1;
          field { desc = "Emit TIMEOUT packets";   sw=rw; hw=r; } TIMEOUT_EN[1:1]    = 1'b1;
          field { desc = "Emit COMPLETION packets"; sw=rw; hw=r; } COMPL_EN[2:2]     = 1'b1;
          field { desc = "Emit THRESHOLD packets"; sw=rw; hw=r; } THRESHOLD_EN[3:3]  = 1'b0;
          field { desc = "Emit PERF packets";      sw=rw; hw=r; } PERF_EN[4:4]       = 1'b0;
          field { desc = "Emit DEBUG packets";     sw=rw; hw=r; } DEBUG_EN[5:5]      = 1'b0;
          field { desc = "Enable the address-range checker. Inert unless OBS_CAPS0.N_ADDR_RANGES > 0.";
                  sw=rw; hw=r; } ADDR_CHECK_EN[6:6] = 1'b0;
          field { desc = "Runtime gate on the per-transaction CAM, ANDed with the build-time
                  ENABLE_MON_TAPS (OBS_CAPS0.MON_TAPS_ARMED). Clear it to stop the tap
                  back-pressuring the datapath: an armed tap gates ready as
                  (block_ready | ~cfg_monitor_enable), so at MAX_TRANSACTIONS the instrument
                  becomes the bottleneck and reports its own limit as the engine's throughput.";
                  sw=rw; hw=r; } MONITOR_EN[7:7] = 1'b1;
          field { sw=r; hw=na; } RSVD[31:8] = 24'h0; } MON_CTRL @ 0x090;

    reg { name = "Monitor timeout"; desc = "Transaction timeout threshold in MICROSECONDS (0 = 0xFFFF, i.e. effectively never)";
          field { sw=rw; hw=r; } TIMEOUT_CYCLES[15:0] = 16'd1024;
          field { sw=r; hw=na; } RSVD[31:16] = 16'h0; } MON_TIMEOUT @ 0x094;

    reg { name = "Monitor latency threshold"; desc = "Latency above which a THRESHOLD packet is raised";
          field { sw=rw; hw=r; } VALUE[31:0] = 32'h0000_FFFF; } MON_LATENCY @ 0x098;

    reg { name = "Monitor perf window"; desc = "Event-driven performance window: pick the start/end events, or drive the triggers by hand";
          field { sw=rw; hw=r; } START_EVENT_SEL[2:0] = 3'd0;
          field { sw=rw; hw=r; } END_EVENT_SEL[6:4]   = 3'd0;
          field { desc = "Manual window open";  sw=rw; hw=r; } START_TRIGGER[8:8] = 1'b0;
          field { desc = "Manual window close"; sw=rw; hw=r; } END_TRIGGER[9:9]   = 1'b0;
          field { desc = "Force the window shut regardless of the end event";
                  sw=rw; hw=r; } FORCE_CLOSE[10:10] = 1'b0;
          field { sw=r; hw=na; } RSVD[31:11] = 21'h0; } MON_WINDOW @ 0x09C;

    //-------------------------------------------------------------------------
    // Address-range checker (0x0A0+)
    //
    // Four ranges, matching the widest the monitors are built for here. A
    // range is [LOW, HIGH] INCLUSIVE. These registers always exist so the map
    // is the same shape on every instance; whether they DO anything depends on
    // N_ADDR_RANGES, which OBS_CAPS0 reports -- it is 0 by default, which
    // compiles the checker out entirely, and that is why ADDR_MATCH packets
    // were unreachable no matter what the host wrote.
    //-------------------------------------------------------------------------
    reg { name = "Address range enable"; desc = "bit[i] = 1 arms range i";
          field { sw=rw; hw=r; } RANGE_EN[3:0] = 4'h0;
          field { sw=r; hw=na; } RSVD[31:4] = 28'h0; } ADDR_RANGE_CTRL @ 0x0A0;

    reg { name = "Range 0 low";  field { sw=rw; hw=r; } VALUE[31:0] = 32'h0; } ADDR_RANGE0_LOW  @ 0x0A4;
    reg { name = "Range 0 high"; field { sw=rw; hw=r; } VALUE[31:0] = 32'h0; } ADDR_RANGE0_HIGH @ 0x0A8;
    reg { name = "Range 1 low";  field { sw=rw; hw=r; } VALUE[31:0] = 32'h0; } ADDR_RANGE1_LOW  @ 0x0AC;
    reg { name = "Range 1 high"; field { sw=rw; hw=r; } VALUE[31:0] = 32'h0; } ADDR_RANGE1_HIGH @ 0x0B0;
    reg { name = "Range 2 low";  field { sw=rw; hw=r; } VALUE[31:0] = 32'h0; } ADDR_RANGE2_LOW  @ 0x0B4;
    reg { name = "Range 2 high"; field { sw=rw; hw=r; } VALUE[31:0] = 32'h0; } ADDR_RANGE2_HIGH @ 0x0B8;
    reg { name = "Range 3 low";  field { sw=rw; hw=r; } VALUE[31:0] = 32'h0; } ADDR_RANGE3_LOW  @ 0x0BC;
    reg { name = "Range 3 high"; field { sw=rw; hw=r; } VALUE[31:0] = 32'h0; } ADDR_RANGE3_HIGH @ 0x0C0;

    //-------------------------------------------------------------------------
    // Capabilities (0x0D0+) -- read-only, driven from parameters
    //
    // What this INSTANCE was built with. Software should read these before
    // concluding anything from a zero counter: an observer whose COMPL cone is
    // absent reports no completions no matter how it is configured, and that
    // is indistinguishable from a broken datapath unless you can ask. Both
    // observers populate these identically.
    //-------------------------------------------------------------------------
    // CAPS PACKING -- read before "improving" these into named fields.
    //
    // These three are single wide hw=w fields, unlike every other register
    // here, and that is deliberate. Each hw=w FIELD becomes its own nested
    // entry in the generated hwif_in struct, and Verilator 5.020 miscompiles
    // the struct port copy once that struct gets wide enough: it emits
    //     u_obs_regs.hwif_in = hwif_i;
    // with the destination typed CData, and g++ rejects it with
    //     cannot convert 'Vtop_obs_regs_top___05Fin_t__struct__0' to 'CData'.
    // Nineteen 1-bit capability fields took hwif_in from 10 members to 29 and
    // tripped exactly that. Verified by bisection: commenting out all 19
    // DRIVERS did not help, so it is the struct shape, not the assignments.
    //
    // `make lint` does NOT catch this -- it never runs C++ codegen. Only a
    // full model build does. Same trap the per-field-drive comment further
    // down warns about.
    reg { name = "Capabilities 0"; desc = "Build-time feature bits, packed. Wide single fields on purpose: see the CAPS PACKING note above.
          [0] ERROR_CONE  [1] TIMEOUT_CONE [2] COMPL_CONE  [3] THRESHOLD_CONE
          [4] PERF_CONE   [5] DEBUG_CONE   [6] MON_TAPS_ARMED [7] BUS_METER
          [8] COMPRESSION [9] EGRESS_AXIL  [10] ID_SLICE   [15:12] N_ADDR_RANGES";
          field { sw=r; hw=w; } VALUE[31:0] = 32'h0; } OBS_CAPS0 @ 0x0D0;

    reg { name = "Capabilities 1"; desc = "Tap geometry, packed.
          [7:0] NUM_RD_PORTS [15:8] NUM_WR_PORTS [23:16] NUM_CHANNELS (per tap) [31:24] CH_BASE";
          field { sw=r; hw=w; } VALUE[31:0] = 32'h0; } OBS_CAPS1 @ 0x0D4;

    reg { name = "Capabilities 2"; desc = "Transaction-table sizing, packed.
          [15:0] MAX_TRANSACTIONS [23:16] NUM_BANKS [31:24] ADDR_WIDTH";
          field { sw=r; hw=w; } VALUE[31:0] = 32'h0; } OBS_CAPS2 @ 0x0D8;
};

addrmap obs_regs_top {
    name = "DMA observer CSRs";
    desc = "APB-fronted configuration for the inline performance observer";
    obs_regs OBS @ 0x000;
};
