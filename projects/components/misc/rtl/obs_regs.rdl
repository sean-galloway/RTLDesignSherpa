// SPDX-License-Identifier: MIT
// SPDX-FileCopyrightText: 2026 sean galloway
//
// Configuration for axi4_dma_observer -- the inline performance-observation
// block on the STREAM datapath.
//
// WHY THIS EXISTS: the observer took 31 cfg_* ports and the harness tied 18 of
// them off to constants. That is the same shape dma_slave_monitors had before
// it grew its own APB: a block whose configuration lives in whoever happens to
// instantiate it, so every harness must know its internals and no host can
// change anything at runtime. With the config local, the harness is reduced to
// instantiation and one bridge slave, which is what lets a SINGLE harness
// source serve both the monitor and the performance builds.
//
// Three protocol groups, because the observer watches three kinds of traffic:
//   AXI   -- the DMA datapath itself
//   AXIS  -- the stream side
//   CORE  -- scheduler / descriptor-engine events
// Each group has the same shape as the in-core monitors' MON regfile
// (stream_mon_regs.rdl) and the slave monitors' (slvmon_regs.rdl), so a host
// that can drive one can drive all three without learning a new idiom.
//
// Mask polarity, stated once because the RDL got it backwards elsewhere:
// PKT_MASK bit[type] = 1 means DROP that packet type (RTL:
// pkt_drop = cfg_axi_pkt_mask[pkt_type]). The per-class masks are indexed by
// event_code[3:0], so they are 16 bits -- not 8, which was the defect that
// made event codes >= 8 unmaskable on the in-core monitors.
//
// Defaults reproduce the harness's previous tie-offs, so this is behaviour
// neutral until a host writes.

regfile obs_regs {
    name = "DMA observer configuration";
    desc = "Runtime config for the inline performance-observation block";

    //-------------------------------------------------------------------------
    // AXI protocol group -- the DMA datapath
    //-------------------------------------------------------------------------
    reg { name = "AXI packet mask"; desc = "bit[type]=1 drops that packet type; ERR_SELECT routes err-FIFO vs bulk";
          field { sw=rw; hw=r; } PKT_MASK[15:0]    = 16'h0000;
          field { sw=rw; hw=r; } ERR_SELECT[31:16] = 16'h0000; } AXI_PKT_MASK @ 0x000;
    reg { name = "AXI mask1"; desc = "Per-event-code drop masks, indexed by event_code[3:0]";
          field { sw=rw; hw=r; } ERROR_MASK[15:0]    = 16'h0000;
          field { sw=rw; hw=r; } TIMEOUT_MASK[31:16] = 16'h0000; } AXI_MASK1 @ 0x004;
    reg { name = "AXI mask2"; desc = "Per-event-code drop masks";
          field { sw=rw; hw=r; } COMPL_MASK[15:0]   = 16'h0000;
          field { sw=rw; hw=r; } THRESH_MASK[31:16] = 16'h0000; } AXI_MASK2 @ 0x008;
    reg { name = "AXI mask3"; desc = "Per-event-code drop masks";
          field { sw=rw; hw=r; } PERF_MASK[15:0]  = 16'h0000;
          field { sw=rw; hw=r; } ADDR_MASK[31:16] = 16'h0000; } AXI_MASK3 @ 0x00C;
    reg { name = "AXI mask4"; desc = "Per-event-code drop masks";
          field { sw=rw; hw=r; } DEBUG_MASK[15:0] = 16'h0000;
          field { sw=r;  hw=na; } RSVD[31:16] = 16'h0; } AXI_MASK4 @ 0x010;

    //-------------------------------------------------------------------------
    // AXIS protocol group -- the stream side
    //-------------------------------------------------------------------------
    reg { name = "AXIS packet mask"; desc = "bit[type]=1 drops that packet type";
          field { sw=rw; hw=r; } PKT_MASK[15:0]    = 16'h0000;
          field { sw=rw; hw=r; } ERR_SELECT[31:16] = 16'h0000; } AXIS_PKT_MASK @ 0x020;
    reg { name = "AXIS mask1"; desc = "Per-event-code drop masks";
          field { sw=rw; hw=r; } ERROR_MASK[15:0]    = 16'h0000;
          field { sw=rw; hw=r; } TIMEOUT_MASK[31:16] = 16'h0000; } AXIS_MASK1 @ 0x024;
    reg { name = "AXIS mask2"; desc = "Per-event-code drop masks";
          field { sw=rw; hw=r; } COMPL_MASK[15:0]    = 16'h0000;
          field { sw=rw; hw=r; } CHANNEL_MASK[31:16] = 16'h0000; } AXIS_MASK2 @ 0x028;
    reg { name = "AXIS mask3"; desc = "Per-event-code drop masks";
          field { sw=rw; hw=r; } CREDIT_MASK[15:0]  = 16'h0000;
          field { sw=rw; hw=r; } STREAM_MASK[31:16] = 16'h0000; } AXIS_MASK3 @ 0x02C;

    //-------------------------------------------------------------------------
    // CORE protocol group -- scheduler / descriptor-engine events
    //-------------------------------------------------------------------------
    reg { name = "CORE packet mask"; desc = "bit[type]=1 drops that packet type";
          field { sw=rw; hw=r; } PKT_MASK[15:0]    = 16'h0000;
          field { sw=rw; hw=r; } ERR_SELECT[31:16] = 16'h0000; } CORE_PKT_MASK @ 0x040;
    reg { name = "CORE mask1"; desc = "Per-event-code drop masks";
          field { sw=rw; hw=r; } ERROR_MASK[15:0]    = 16'h0000;
          field { sw=rw; hw=r; } TIMEOUT_MASK[31:16] = 16'h0000; } CORE_MASK1 @ 0x044;
    reg { name = "CORE mask2"; desc = "Per-event-code drop masks";
          field { sw=rw; hw=r; } COMPL_MASK[15:0]   = 16'h0000;
          field { sw=rw; hw=r; } THRESH_MASK[31:16] = 16'h0000; } CORE_MASK2 @ 0x048;
    reg { name = "CORE mask3"; desc = "Per-event-code drop masks";
          field { sw=rw; hw=r; } PERF_MASK[15:0]  = 16'h0000;
          field { sw=rw; hw=r; } DEBUG_MASK[31:16] = 16'h0000; } CORE_MASK3 @ 0x04C;

    //-------------------------------------------------------------------------
    // Group-level controls
    //-------------------------------------------------------------------------
    reg { name = "Observer control"; desc = "Monbus group drain + compression";
          field { desc = "Bulk-write flush watermark"; sw=rw; hw=r; } FLUSH_WATERMARK[15:0] = 16'h0010;
          field { desc = "1 = compress the monbus write stream. The tally reassembles RAW 3-beat records, so leave 0 unless the consumer decompresses.";
                  sw=rw; hw=r; } COMPRESS_EN[16:16] = 1'b0;
          field { desc = "counter_freq_invariant LUT index, used only when FREQ_SEL_OVR=1. The LUT is 60+5*i MHz, so 4=80, 6=90, 8=100, 12=120.";
                  sw=rw; hw=r; } FREQ_SEL[20:17] = 4'h0;
          field { desc = "0 = use the build-time index derived from ACLK_MHZ (correct at reset for any build frequency); 1 = use FREQ_SEL instead. Exists so the reset value cannot silently disagree with the actual clock.";
                  sw=rw; hw=r; } FREQ_SEL_OVR[21:21] = 1'b0;
          field { sw=r; hw=na; } RSVD[31:22] = 10'h0; } OBS_CTRL @ 0x060;

    reg { name = "Observer window base";  desc = "Monbus bulk-write window low bound";
          field { sw=rw; hw=r; } VALUE[31:0] = 32'h0004_0000; } OBS_BASE_ADDR  @ 0x064;
    reg { name = "Observer window limit"; desc = "Monbus bulk-write window high bound";
          field { sw=rw; hw=r; } VALUE[31:0] = 32'h0007_FFFF; } OBS_LIMIT_ADDR @ 0x068;

    //-------------------------------------------------------------------------
    // Telemetry readback (0x070+)
    //
    // The meters, latency histograms and perf counters are PER TAP and PER
    // CHANNEL, so exposing them flat would be hundreds of registers -- and
    // exposing them as PORTS (what this block used to do) cost 70 tie-offs per
    // instance, every one of them a silent break if forgotten. Indexed
    // select/data instead, the same shape stream_regs uses for HIST_SEL /
    // HIST_DATA.
    //
    // Write OBS_STAT_SEL, then read OBS_STAT_DATA. The selection is registered
    // in hardware, so the read returns the addressed counter with no side
    // effects and re-reading is safe.
    //
    // IDENTICAL IN BOTH OBSERVERS. The master and slave observers differ only
    // in which monitor flavour they instantiate; their register map is the
    // same file, so one host decoder and one regmap serve both.
    //-------------------------------------------------------------------------
    reg { name = "Telemetry select"; desc = "Addresses one telemetry counter for OBS_STAT_DATA";
          field { desc = "Tap index (0..NUM_RD_PORTS-1 for read metrics, 0..NUM_WR_PORTS-1 for write)";
                  sw=rw; hw=r; } TAP[7:0] = 8'h00;
          field { desc = "Channel index within the tap; ignored for aggregate metrics";
                  sw=rw; hw=r; } CHANNEL[15:8] = 8'h00;
          field { desc = "Metric id. AGGREGATE (per tap): 0=productive, 1=backpressure, 2=starvation, 3=idle. PER CHANNEL (uses CHANNEL): 4=productive, 5=backpressure, 6=starvation, 7=idle, 8=overflow. HISTOGRAM: 9=bin (NOT YET READABLE - the bin is chosen by the i_hist_bin input port, so BIN here is accepted and ignored and this reads 0), 10=total. Any other value reads 0.";
                  sw=rw; hw=r; } METRIC[23:16] = 8'h00;
          field { desc = "0 = read-side metric, 1 = write-side"; sw=rw; hw=r; } IS_WRITE[24:24] = 1'b0;
          field { desc = "Histogram bin index, used when METRIC=9"; sw=rw; hw=r; } BIN[30:25] = 6'h00;
          field { desc = "Which latency metric the histogram reports (e.g. AR->firstR vs AR->RLAST). SEPARATE from IS_WRITE, which selects the read- or write-side array -- conflating them makes half the histogram unreachable.";
                  sw=rw; hw=r; } HIST_METRIC[31:31] = 1'b0;
        } OBS_STAT_SEL @ 0x070;

    reg { name = "Telemetry data"; desc = "The counter addressed by OBS_STAT_SEL. Reads as 0 for a metric this instance does not build (meters/histograms are parameter-gated).";
          field { sw=r; hw=w; } VALUE[31:0] = 32'h0; } OBS_STAT_DATA @ 0x074;

    reg { name = "Monbus FIFO status"; desc = "Group err/write FIFO occupancy and full flags";
          field { sw=r; hw=w; } ERR_COUNT[15:0]   = 16'h0;
          field { sw=r; hw=w; } WRITE_COUNT[30:16] = 15'h0;
          field { desc = "Either FIFO full"; sw=r; hw=w; } ANY_FULL[31:31] = 1'b0;
        } OBS_FIFO_STAT @ 0x078;

    reg { name = "Observer sticky status"; desc = "Sticky flags. A dropped sample or a blocked tap means the numbers above are INCOMPLETE, so it has to be readable alongside them.";
          field { desc = "A latency-histogram timestamp was dropped"; sw=r; hw=w; } HIST_SAMPLE_LOST[0:0] = 1'b0;
          field { desc = "Any tap asserted block_ready (its table filled, so it stopped tracking)"; sw=r; hw=w; } TAP_BLOCKED[1:1] = 1'b0;
          field { sw=r; hw=na; } RSVD[31:2] = 30'h0; } OBS_STICKY @ 0x07C;

    reg { name = "Compressor stats"; desc = "monbus_compressor tier hits and CAM misses";
          field { sw=r; hw=w; } TIER1[15:0] = 16'h0;
          field { sw=r; hw=w; } TIER0[31:16] = 16'h0; } OBS_COMP_STAT0 @ 0x080;
    reg { name = "Compressor stats 2"; desc = "CAM miss and overflow counters";
          field { sw=r; hw=w; } CAM_MISS[15:0] = 16'h0;
          field { sw=r; hw=w; } OVERFLOW[31:16] = 16'h0; } OBS_COMP_STAT1 @ 0x084;
};

addrmap obs_regs_top {
    name = "DMA observer CSRs";
    desc = "APB-fronted configuration for the inline performance observer";
    obs_regs OBS @ 0x000;
};
