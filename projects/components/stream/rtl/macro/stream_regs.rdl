// SPDX-License-Identifier: MIT
// SPDX-FileCopyrightText: 2024-2025 sean galloway
//
// STREAM Register Definition - PeakRDL Format
// Enhanced with full monitor configuration fields
//
// Address Space Layout:
//   0x000 - 0x03F: Channel kick-off registers (handled by apbtodescr.sv)
//                  - 16 registers: CHx_CTRL_LOW + CHx_CTRL_HIGH for 8 channels
//                  - 64-bit descriptor addresses split across LOW/HIGH pairs
//   0x100 - 0x3FF: Control and status registers (this file)
//
// Notes:
//   - Channel kick-off registers (CHx_CTRL) are NOT defined here
//   - Those are routed directly to descriptor engines via apbtodescr.sv
//   - This file defines all other configuration and status registers
//   - Includes full monitor mask and threshold registers
//
// Author: sean galloway
// Created: 2025-11-21

addrmap stream_regs {
    name = "STREAM DMA Engine Registers";
    desc = "Configuration and status registers for 8-channel STREAM DMA engine with full monitor control";

    default regwidth = 32;
    default accesswidth = 32;
    default alignment = 4;

    //=========================================================================
    // Global Control and Status (0x100 - 0x11F)
    //=========================================================================

    reg {
        name = "Global Control Register";
        desc = "Master enable and global configuration";

        field {
            desc = "Global enable - master switch for entire STREAM engine";
            sw = rw;
            hw = r;
        } GLOBAL_EN = 1'b0;

        field {
            desc = "Global reset - resets all channels and state machines";
            sw = rw;
            hw = r;
            swmod;  // Self-clearing
        } GLOBAL_RST = 1'b0;

        field {
            desc = "Reserved";
            sw = r;
            hw = na;
        } RSVD[31:2] = 30'h0;

    } GLOBAL_CTRL @ 0x100;

    reg {
        name = "Global Status Register";
        desc = "Overall system status and error flags";

        field {
            desc = "System idle - all channels idle";
            sw = r;
            hw = w;
        } SYSTEM_IDLE;

        field {
            desc = "Reserved";
            sw = r;
            hw = na;
        } RSVD[31:1] = 31'h0;

    } GLOBAL_STATUS @ 0x104;

    reg {
        name = "Version Register";
        desc = "STREAM version and configuration information";

        field {
            desc = "Minor version";
            sw = r;
            hw = na;
        } MINOR[7:0] = 8'd90;  // 0.90

        field {
            desc = "Major version";
            sw = r;
            hw = na;
        } MAJOR[15:8] = 8'h00;  // 0.90 (pre-release)

        field {
            desc = "Number of channels";
            sw = r;
            hw = na;
        } NUM_CHANNELS[23:16] = 8'h08;

        field {
            desc = "Reserved";
            sw = r;
            hw = na;
        } RSVD[31:24] = 8'h0;

    } VERSION @ 0x108;

    //=========================================================================
    // Per-Channel Control (0x120 - 0x13F)
    //=========================================================================

    reg {
        name = "Channel Enable Register";
        desc = "Per-channel enable bits (one bit per channel)";

        field {
            desc = "Channel enable bits [7:0] - 1=enabled, 0=disabled";
            sw = rw;
            hw = r;
        } CH_EN[7:0] = 8'h00;

        field {
            desc = "Reserved";
            sw = r;
            hw = na;
        } RSVD[31:8] = 24'h0;

    } CHANNEL_ENABLE @ 0x120;

    reg {
        name = "Channel Reset Register";
        desc = "Per-channel reset bits (one bit per channel, self-clearing)";

        field {
            desc = "Channel reset bits [7:0] - write 1 to reset channel";
            sw = rw;
            hw = r;
            swmod;  // Self-clearing
        } CH_RST[7:0] = 8'h00;

        field {
            desc = "Reserved";
            sw = r;
            hw = na;
        } RSVD[31:8] = 24'h0;

    } CHANNEL_RESET @ 0x124;

    //=========================================================================
    // Per-Channel Status (0x140 - 0x17F)
    //=========================================================================

    reg {
        name = "Channel Idle Status";
        desc = "Per-channel idle status (one bit per channel)";

        field {
            desc = "Channel idle bits [7:0] - 1=idle, 0=active";
            sw = r;
            hw = w;
        } CH_IDLE[7:0];

        field {
            desc = "Reserved";
            sw = r;
            hw = na;
        } RSVD[31:8] = 24'h0;

    } CHANNEL_IDLE @ 0x140;

    reg {
        name = "Descriptor Engine Idle Status";
        desc = "Per-channel descriptor engine idle status";

        field {
            desc = "Descriptor engine idle bits [7:0] - 1=idle, 0=active";
            sw = r;
            hw = w;
        } DESC_IDLE[7:0];

        field {
            desc = "Reserved";
            sw = r;
            hw = na;
        } RSVD[31:8] = 24'h0;

    } DESC_ENGINE_IDLE @ 0x144;

    reg {
        name = "Scheduler Idle Status";
        desc = "Per-channel scheduler idle status";

        field {
            desc = "Scheduler idle bits [7:0] - 1=idle, 0=active";
            sw = r;
            hw = w;
        } SCHED_IDLE[7:0];

        field {
            desc = "Reserved";
            sw = r;
            hw = na;
        } RSVD[31:8] = 24'h0;

    } SCHEDULER_IDLE @ 0x148;

    // Per-channel state registers (CH0-CH7)
    regfile {
        name = "Per-Channel State Registers";
        desc = "Detailed state for individual channel";

        reg {
            name = "Channel State";
            desc = "Current FSM state of scheduler (one-hot 7-bit encoding)";

            field {
                desc = "Scheduler state [6:0] - one-hot encoding";
                sw = r;
                hw = w;
            } STATE[6:0];

            field {
                desc = "Reserved";
                sw = r;
                hw = na;
            } RSVD[31:7] = 25'h0;

        } STATE @ 0x0;

    } CH_STATE[8] @ 0x150 += 0x4;

    //=========================================================================
    // Engine Completion and Error Status (0x170 - 0x17F)
    //=========================================================================

    reg {
        name = "Scheduler Error Status";
        desc = "Per-channel scheduler error flags";

        field {
            desc = "Scheduler error bits [7:0] - 1=error detected, 0=no error";
            sw = r;
            hw = w;
        } SCHED_ERR[7:0];

        field {
            desc = "Reserved";
            sw = r;
            hw = na;
        } RSVD[31:8] = 24'h0;

    } SCHED_ERROR @ 0x170;

    reg {
        name = "AXI Read Engine Completion Status";
        desc = "Per-channel read engine all_complete flags";

        field {
            desc = "Read completion bits [7:0] - 1=all reads complete, 0=reads pending";
            sw = r;
            hw = w;
        } RD_COMPLETE[7:0];

        field {
            desc = "Reserved";
            sw = r;
            hw = na;
        } RSVD[31:8] = 24'h0;

    } AXI_RD_COMPLETE @ 0x174;

    reg {
        name = "AXI Write Engine Completion Status";
        desc = "Per-channel write engine all_complete flags";

        field {
            desc = "Write completion bits [7:0] - 1=all writes complete, 0=writes pending";
            sw = r;
            hw = w;
        } WR_COMPLETE[7:0];

        field {
            desc = "Reserved";
            sw = r;
            hw = na;
        } RSVD[31:8] = 24'h0;

    } AXI_WR_COMPLETE @ 0x178;

    //=========================================================================
    // Monitor Status (0x180 - 0x1FF) - When USE_AXI_MONITORS=1
    //=========================================================================

    reg {
        name = "Monitor FIFO Status";
        desc = "Monitor bus FIFO status indicators";

        field {
            desc = "Monitor FIFO full - 1=FIFO full, 0=space available";
            sw = r;
            hw = w;
        } MON_FIFO_FULL;

        field {
            desc = "Monitor FIFO empty - 1=FIFO empty, 0=data available";
            sw = r;
            hw = w;
        } MON_FIFO_EMPTY;

        field {
            desc = "Monitor FIFO overflow - 1=overflow detected, 0=normal";
            sw = r;
            hw = w;
        } MON_FIFO_OVFL;

        field {
            desc = "Monitor FIFO underflow - 1=underflow detected, 0=normal";
            sw = r;
            hw = w;
        } MON_FIFO_UNFL;

        field {
            desc = "Reserved";
            sw = r;
            hw = na;
        } RSVD[31:4] = 28'h0;

    } MON_FIFO_STATUS @ 0x180;

    reg {
        name = "Monitor FIFO Count";
        desc = "Monitor bus FIFO entry count";

        field {
            desc = "FIFO count [15:0] - number of entries in FIFO";
            sw = r;
            hw = w;
        } FIFO_COUNT[15:0];

        field {
            desc = "Reserved";
            sw = r;
            hw = na;
        } RSVD[31:16] = 16'h0;

    } MON_FIFO_COUNT @ 0x184;

    //=========================================================================
    // Scheduler Configuration (0x200 - 0x21F)
    //=========================================================================

    reg {
        name = "Scheduler Timeout Cycles";
        desc = "Timeout threshold in clock cycles (global for all channels)";

        field {
            desc = "Timeout cycles [15:0] - number of cycles before timeout";
            sw = rw;
            hw = r;
        } TIMEOUT_CYCLES[15:0] = 16'd1000;

        field {
            desc = "Reserved";
            sw = r;
            hw = na;
        } RSVD[31:16] = 16'h0;

    } SCHED_TIMEOUT_CYCLES @ 0x200;

    reg {
        name = "Scheduler Configuration";
        desc = "Scheduler feature enables (global for all channels)";

        field {
            desc = "Scheduler enable - master scheduler enable";
            sw = rw;
            hw = r;
        } SCHED_EN = 1'b1;

        field {
            desc = "Timeout enable - enable timeout detection";
            sw = rw;
            hw = r;
        } TIMEOUT_EN = 1'b1;

        field {
            desc = "Error enable - enable error reporting";
            sw = rw;
            hw = r;
        } ERR_EN = 1'b1;

        field {
            desc = "Completion enable - enable completion reporting";
            sw = rw;
            hw = r;
        } COMPL_EN = 1'b1;

        field {
            desc = "Performance enable - enable performance monitoring";
            sw = rw;
            hw = r;
        } PERF_EN = 1'b0;

        field {
            desc = "Reserved";
            sw = r;
            hw = na;
        } RSVD[31:5] = 27'h0;

    } SCHED_CONFIG @ 0x204;

    //=========================================================================
    // Descriptor Engine Configuration (0x220 - 0x23F)
    //=========================================================================

    reg {
        name = "Descriptor Engine Configuration";
        desc = "Descriptor engine feature enables (global for all channels)";

        field {
            desc = "Descriptor engine enable - master enable";
            sw = rw;
            hw = r;
        } DESCENG_EN = 1'b1;

        field {
            desc = "Prefetch enable - enable descriptor prefetch";
            sw = rw;
            hw = r;
        } PREFETCH_EN = 1'b0;

        field {
            desc = "FIFO threshold [5:2] - prefetch threshold (4 bits)";
            sw = rw;
            hw = r;
        } FIFO_THRESH[5:2] = 4'h8;

        field {
            desc = "Reserved";
            sw = r;
            hw = na;
        } RSVD[31:6] = 26'h0;

    } DESCENG_CONFIG @ 0x220;

    reg {
        name = "Descriptor Address Range 0 Base";
        desc = "Base address for descriptor address range 0 (lower 32 bits)";

        field {
            desc = "Address range 0 base [31:0]";
            sw = rw;
            hw = r;
        } ADDR0_BASE[31:0] = 32'h0000_0000;

    } DESCENG_ADDR0_BASE @ 0x224;

    reg {
        name = "Descriptor Address Range 0 Limit";
        desc = "Limit address for descriptor address range 0 (lower 32 bits)";

        field {
            desc = "Address range 0 limit [31:0]";
            sw = rw;
            hw = r;
        } ADDR0_LIMIT[31:0] = 32'hFFFF_FFFF;

    } DESCENG_ADDR0_LIMIT @ 0x228;

    reg {
        name = "Descriptor Address Range 1 Base";
        desc = "Base address for descriptor address range 1 (lower 32 bits)";

        field {
            desc = "Address range 1 base [31:0]";
            sw = rw;
            hw = r;
        } ADDR1_BASE[31:0] = 32'h0000_0000;

    } DESCENG_ADDR1_BASE @ 0x22C;

    reg {
        name = "Descriptor Address Range 1 Limit";
        desc = "Limit address for descriptor address range 1 (lower 32 bits)";

        field {
            desc = "Address range 1 limit [31:0]";
            sw = rw;
            hw = r;
        } ADDR1_LIMIT[31:0] = 32'hFFFF_FFFF;

    } DESCENG_ADDR1_LIMIT @ 0x230;

    //=========================================================================
    // Descriptor AXI Monitor Configuration (0x240 - 0x25F)
    //=========================================================================

    reg {
        name = "Descriptor AXI Monitor Enable";
        desc = "Descriptor AXI master monitor enable controls";

        field {
            desc = "Monitor enable - master enable for descriptor monitor";
            sw = rw;
            hw = r;
        } MON_EN = 1'b1;

        field {
            desc = "Error enable - enable error detection";
            sw = rw;
            hw = r;
        } ERR_EN = 1'b1;

        field {
            desc = "Completion enable - enable completion packets";
            sw = rw;
            hw = r;
        } COMPL_EN = 1'b0;

        field {
            desc = "Timeout enable - enable timeout detection";
            sw = rw;
            hw = r;
        } TIMEOUT_EN = 1'b1;

        field {
            desc = "Performance enable - enable performance packets";
            sw = rw;
            hw = r;
        } PERF_EN = 1'b0;

        field {
            desc = "Reserved";
            sw = r;
            hw = na;
        } RSVD[31:5] = 27'h0;

    } DAXMON_ENABLE @ 0x240;

    reg {
        name = "Descriptor AXI Monitor Timeout";
        desc = "Descriptor AXI monitor timeout threshold (cycles)";

        field {
            desc = "Timeout cycles [31:0]";
            sw = rw;
            hw = r;
        } TIMEOUT_CYCLES[31:0] = 32'd10000;

    } DAXMON_TIMEOUT @ 0x244;

    reg {
        name = "Descriptor AXI Monitor Latency Threshold";
        desc = "Descriptor AXI monitor latency threshold (cycles)";

        field {
            desc = "Latency threshold cycles [31:0]";
            sw = rw;
            hw = r;
        } LATENCY_THRESH[31:0] = 32'd5000;

    } DAXMON_LATENCY_THRESH @ 0x248;

    reg {
        name = "Descriptor AXI Monitor Packet Mask";
        desc = "Descriptor AXI monitor packet type filtering (16-bit mask)";

        field {
            desc = "Packet type mask [15:0] - 1=enable, 0=disable";
            sw = rw;
            hw = r;
        } PKT_MASK[15:0] = 16'hFFFF;

        field {
            desc = "Reserved";
            sw = r;
            hw = na;
        } RSVD[31:16] = 16'h0;

    } DAXMON_PKT_MASK @ 0x24C;

    reg {
        name = "Descriptor AXI Monitor Error Select and Mask";
        desc = "Descriptor AXI monitor error selection and filtering";

        field {
            desc = "Error select [3:0] - error type selection";
            sw = rw;
            hw = r;
        } ERR_SELECT[3:0] = 4'h0;

        field {
            desc = "Reserved";
            sw = r;
            hw = na;
        } RSVD1[7:4] = 4'h0;

        field {
            desc = "Error mask [15:8] - error type filtering";
            sw = rw;
            hw = r;
        } ERR_MASK[15:8] = 8'hFF;

        field {
            desc = "Reserved";
            sw = r;
            hw = na;
        } RSVD2[31:16] = 16'h0;

    } DAXMON_ERR_CFG @ 0x250;

    reg {
        name = "Descriptor AXI Monitor Masks 1";
        desc = "Descriptor AXI monitor timeout and completion masks";

        field {
            desc = "Timeout mask [7:0]";
            sw = rw;
            hw = r;
        } TIMEOUT_MASK[7:0] = 8'hFF;

        field {
            desc = "Completion mask [15:8]";
            sw = rw;
            hw = r;
        } COMPL_MASK[15:8] = 8'h00;

        field {
            desc = "Reserved";
            sw = r;
            hw = na;
        } RSVD[31:16] = 16'h0;

    } DAXMON_MASK1 @ 0x254;

    reg {
        name = "Descriptor AXI Monitor Masks 2";
        desc = "Descriptor AXI monitor threshold and performance masks";

        field {
            desc = "Threshold mask [7:0]";
            sw = rw;
            hw = r;
        } THRESH_MASK[7:0] = 8'hFF;

        field {
            desc = "Performance mask [15:8]";
            sw = rw;
            hw = r;
        } PERF_MASK[15:8] = 8'h00;

        field {
            desc = "Reserved";
            sw = r;
            hw = na;
        } RSVD[31:16] = 16'h0;

    } DAXMON_MASK2 @ 0x258;

    reg {
        name = "Descriptor AXI Monitor Masks 3";
        desc = "Descriptor AXI monitor address and debug masks";

        field {
            desc = "Address mask [7:0]";
            sw = rw;
            hw = r;
        } ADDR_MASK[7:0] = 8'hFF;

        field {
            desc = "Debug mask [15:8]";
            sw = rw;
            hw = r;
        } DEBUG_MASK[15:8] = 8'h00;

        field {
            desc = "Reserved";
            sw = r;
            hw = na;
        } RSVD[31:16] = 16'h0;

    } DAXMON_MASK3 @ 0x25C;

    //=========================================================================
    // Read Engine AXI Monitor Configuration (0x260 - 0x27F)
    //=========================================================================

    reg {
        name = "Read Engine AXI Monitor Enable";
        desc = "Read engine AXI master monitor enable controls";

        field {
            desc = "Monitor enable - master enable for read monitor";
            sw = rw;
            hw = r;
        } MON_EN = 1'b1;

        field {
            desc = "Error enable - enable error detection";
            sw = rw;
            hw = r;
        } ERR_EN = 1'b1;

        field {
            desc = "Completion enable - enable completion packets";
            sw = rw;
            hw = r;
        } COMPL_EN = 1'b0;

        field {
            desc = "Timeout enable - enable timeout detection";
            sw = rw;
            hw = r;
        } TIMEOUT_EN = 1'b1;

        field {
            desc = "Performance enable - enable performance packets";
            sw = rw;
            hw = r;
        } PERF_EN = 1'b0;

        field {
            desc = "Reserved";
            sw = r;
            hw = na;
        } RSVD[31:5] = 27'h0;

    } RDMON_ENABLE @ 0x260;

    reg {
        name = "Read Engine AXI Monitor Timeout";
        desc = "Read engine AXI monitor timeout threshold (cycles)";

        field {
            desc = "Timeout cycles [31:0]";
            sw = rw;
            hw = r;
        } TIMEOUT_CYCLES[31:0] = 32'd10000;

    } RDMON_TIMEOUT @ 0x264;

    reg {
        name = "Read Engine AXI Monitor Latency Threshold";
        desc = "Read engine AXI monitor latency threshold (cycles)";

        field {
            desc = "Latency threshold cycles [31:0]";
            sw = rw;
            hw = r;
        } LATENCY_THRESH[31:0] = 32'd5000;

    } RDMON_LATENCY_THRESH @ 0x268;

    reg {
        name = "Read Engine AXI Monitor Packet Mask";
        desc = "Read engine AXI monitor packet type filtering (16-bit mask)";

        field {
            desc = "Packet type mask [15:0] - 1=enable, 0=disable";
            sw = rw;
            hw = r;
        } PKT_MASK[15:0] = 16'hFFFF;

        field {
            desc = "Reserved";
            sw = r;
            hw = na;
        } RSVD[31:16] = 16'h0;

    } RDMON_PKT_MASK @ 0x26C;

    reg {
        name = "Read Engine AXI Monitor Error Select and Mask";
        desc = "Read engine AXI monitor error selection and filtering";

        field {
            desc = "Error select [3:0] - error type selection";
            sw = rw;
            hw = r;
        } ERR_SELECT[3:0] = 4'h0;

        field {
            desc = "Reserved";
            sw = r;
            hw = na;
        } RSVD1[7:4] = 4'h0;

        field {
            desc = "Error mask [15:8] - error type filtering";
            sw = rw;
            hw = r;
        } ERR_MASK[15:8] = 8'hFF;

        field {
            desc = "Reserved";
            sw = r;
            hw = na;
        } RSVD2[31:16] = 16'h0;

    } RDMON_ERR_CFG @ 0x270;

    reg {
        name = "Read Engine AXI Monitor Masks 1";
        desc = "Read engine AXI monitor timeout and completion masks";

        field {
            desc = "Timeout mask [7:0]";
            sw = rw;
            hw = r;
        } TIMEOUT_MASK[7:0] = 8'hFF;

        field {
            desc = "Completion mask [15:8]";
            sw = rw;
            hw = r;
        } COMPL_MASK[15:8] = 8'h00;

        field {
            desc = "Reserved";
            sw = r;
            hw = na;
        } RSVD[31:16] = 16'h0;

    } RDMON_MASK1 @ 0x274;

    reg {
        name = "Read Engine AXI Monitor Masks 2";
        desc = "Read engine AXI monitor threshold and performance masks";

        field {
            desc = "Threshold mask [7:0]";
            sw = rw;
            hw = r;
        } THRESH_MASK[7:0] = 8'hFF;

        field {
            desc = "Performance mask [15:8]";
            sw = rw;
            hw = r;
        } PERF_MASK[15:8] = 8'h00;

        field {
            desc = "Reserved";
            sw = r;
            hw = na;
        } RSVD[31:16] = 16'h0;

    } RDMON_MASK2 @ 0x278;

    reg {
        name = "Read Engine AXI Monitor Masks 3";
        desc = "Read engine AXI monitor address and debug masks";

        field {
            desc = "Address mask [7:0]";
            sw = rw;
            hw = r;
        } ADDR_MASK[7:0] = 8'hFF;

        field {
            desc = "Debug mask [15:8]";
            sw = rw;
            hw = r;
        } DEBUG_MASK[15:8] = 8'h00;

        field {
            desc = "Reserved";
            sw = r;
            hw = na;
        } RSVD[31:16] = 16'h0;

    } RDMON_MASK3 @ 0x27C;

    //=========================================================================
    // Write Engine AXI Monitor Configuration (0x280 - 0x29F)
    //=========================================================================

    reg {
        name = "Write Engine AXI Monitor Enable";
        desc = "Write engine AXI master monitor enable controls";

        field {
            desc = "Monitor enable - master enable for write monitor";
            sw = rw;
            hw = r;
        } MON_EN = 1'b1;

        field {
            desc = "Error enable - enable error detection";
            sw = rw;
            hw = r;
        } ERR_EN = 1'b1;

        field {
            desc = "Completion enable - enable completion packets";
            sw = rw;
            hw = r;
        } COMPL_EN = 1'b0;

        field {
            desc = "Timeout enable - enable timeout detection";
            sw = rw;
            hw = r;
        } TIMEOUT_EN = 1'b1;

        field {
            desc = "Performance enable - enable performance packets";
            sw = rw;
            hw = r;
        } PERF_EN = 1'b0;

        field {
            desc = "Reserved";
            sw = r;
            hw = na;
        } RSVD[31:5] = 27'h0;

    } WRMON_ENABLE @ 0x280;

    reg {
        name = "Write Engine AXI Monitor Timeout";
        desc = "Write engine AXI monitor timeout threshold (cycles)";

        field {
            desc = "Timeout cycles [31:0]";
            sw = rw;
            hw = r;
        } TIMEOUT_CYCLES[31:0] = 32'd10000;

    } WRMON_TIMEOUT @ 0x284;

    reg {
        name = "Write Engine AXI Monitor Latency Threshold";
        desc = "Write engine AXI monitor latency threshold (cycles)";

        field {
            desc = "Latency threshold cycles [31:0]";
            sw = rw;
            hw = r;
        } LATENCY_THRESH[31:0] = 32'd5000;

    } WRMON_LATENCY_THRESH @ 0x288;

    reg {
        name = "Write Engine AXI Monitor Packet Mask";
        desc = "Write engine AXI monitor packet type filtering (16-bit mask)";

        field {
            desc = "Packet type mask [15:0] - 1=enable, 0=disable";
            sw = rw;
            hw = r;
        } PKT_MASK[15:0] = 16'hFFFF;

        field {
            desc = "Reserved";
            sw = r;
            hw = na;
        } RSVD[31:16] = 16'h0;

    } WRMON_PKT_MASK @ 0x28C;

    reg {
        name = "Write Engine AXI Monitor Error Select and Mask";
        desc = "Write engine AXI monitor error selection and filtering";

        field {
            desc = "Error select [3:0] - error type selection";
            sw = rw;
            hw = r;
        } ERR_SELECT[3:0] = 4'h0;

        field {
            desc = "Reserved";
            sw = r;
            hw = na;
        } RSVD1[7:4] = 4'h0;

        field {
            desc = "Error mask [15:8] - error type filtering";
            sw = rw;
            hw = r;
        } ERR_MASK[15:8] = 8'hFF;

        field {
            desc = "Reserved";
            sw = r;
            hw = na;
        } RSVD2[31:16] = 16'h0;

    } WRMON_ERR_CFG @ 0x290;

    reg {
        name = "Write Engine AXI Monitor Masks 1";
        desc = "Write engine AXI monitor timeout and completion masks";

        field {
            desc = "Timeout mask [7:0]";
            sw = rw;
            hw = r;
        } TIMEOUT_MASK[7:0] = 8'hFF;

        field {
            desc = "Completion mask [15:8]";
            sw = rw;
            hw = r;
        } COMPL_MASK[15:8] = 8'h00;

        field {
            desc = "Reserved";
            sw = r;
            hw = na;
        } RSVD[31:16] = 16'h0;

    } WRMON_MASK1 @ 0x294;

    reg {
        name = "Write Engine AXI Monitor Masks 2";
        desc = "Write engine AXI monitor threshold and performance masks";

        field {
            desc = "Threshold mask [7:0]";
            sw = rw;
            hw = r;
        } THRESH_MASK[7:0] = 8'hFF;

        field {
            desc = "Performance mask [15:8]";
            sw = rw;
            hw = r;
        } PERF_MASK[15:8] = 8'h00;

        field {
            desc = "Reserved";
            sw = r;
            hw = na;
        } RSVD[31:16] = 16'h0;

    } WRMON_MASK2 @ 0x298;

    reg {
        name = "Write Engine AXI Monitor Masks 3";
        desc = "Write engine AXI monitor address and debug masks";

        field {
            desc = "Address mask [7:0]";
            sw = rw;
            hw = r;
        } ADDR_MASK[7:0] = 8'hFF;

        field {
            desc = "Debug mask [15:8]";
            sw = rw;
            hw = r;
        } DEBUG_MASK[15:8] = 8'h00;

        field {
            desc = "Reserved";
            sw = r;
            hw = na;
        } RSVD[31:16] = 16'h0;

    } WRMON_MASK3 @ 0x29C;

    //=========================================================================
    // AXI Transfer Configuration (0x2A0 - 0x2AF)
    //=========================================================================

    reg {
        name = "AXI Transfer Configuration";
        desc = "AXI read and write transfer burst sizes";

        field {
            desc = "AXI read transfer beats [7:0] - ARLEN value (0-255 represents 1-256 beats)";
            sw = rw;
            hw = r;
        } RD_XFER_BEATS[7:0] = 8'd15;

        field {
            desc = "AXI write transfer beats [15:8] - AWLEN value (0-255 represents 1-256 beats)";
            sw = rw;
            hw = r;
        } WR_XFER_BEATS[15:8] = 8'd15;

        field {
            desc = "Reserved";
            sw = r;
            hw = na;
        } RSVD[31:16] = 16'h0;

    } AXI_XFER_CONFIG @ 0x2A0;

    //=========================================================================
    // Performance Profiler Configuration (0x2B0 - 0x2BF)
    //=========================================================================

    reg {
        name = "Performance Profiler Configuration";
        desc = "Performance profiler enable and mode controls";

        field {
            desc = "Performance profiler enable";
            sw = rw;
            hw = r;
        } PERF_EN = 1'b0;

        field {
            desc = "Performance profiler mode - 0=count, 1=histogram";
            sw = rw;
            hw = r;
        } PERF_MODE = 1'b0;

        field {
            desc = "Performance profiler clear - write 1 to clear counters";
            sw = rw;
            hw = r;
            swmod;  // Self-clearing
        } PERF_CLEAR = 1'b0;

        field {
            desc = "Reserved";
            sw = r;
            hw = na;
        } RSVD[31:3] = 29'h0;

    } PERF_CONFIG @ 0x2B0;

};
