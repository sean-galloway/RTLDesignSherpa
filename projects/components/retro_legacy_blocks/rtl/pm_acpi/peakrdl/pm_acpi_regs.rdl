/**
 * SystemRDL Definition for PM_ACPI (Power Management ACPI) Controller Registers
 *
 * This specification defines the register interface for ACPI-compatible power
 * management functionality, providing system-level power control, PM timer,
 * and general-purpose event handling.
 *
 * Key Features:
 * - ACPI-compatible PM1 control and status registers
 * - 32-bit PM Timer (3.579545 MHz equivalent via configurable divider)
 * - General Purpose Event (GPE) registers with 32 event sources
 * - Clock gating control for up to 32 clock domains
 * - Power domain sequencing control for up to 8 domains
 * - Wake event handling and configuration
 * - Power state management (S0/S1/S3)
 * - Interrupt aggregation for power events
 *
 * Power States:
 * - S0: Working state (full power, all clocks active)
 * - S1: Sleep state (clock gating, quick wake, context retained)
 * - S3: Deep sleep (power domains off, context lost, wake from events)
 *
 * GH#54 review follow-up (2026-09-09):
 * - ACPI_CONTROL.acpi_enable is the SCI_EN gate: GPE capture and the
 *   pm_interrupt PIN. PM1/WAKE status still record with ACPI disabled.
 * - PM1_STATUS.rtc_sts and WAKE_STATUS.rtc_wake/.ext_wake are set on the
 *   synchronized ASSERTION EDGE of their pin, like GPE and the buttons, so a
 *   W1C takes effect while the pin is still held.
 * - ACPI_INT_STATUS is an unconditional per-source EVENT LOG, not a pending
 *   mirror; it does not drive pm_interrupt.
 *
 * GH#54 register contract (2026-09-09):
 * - Every W1C status field (ACPI_STATUS, ACPI_INT_STATUS, PM1_STATUS,
 *   WAKE_STATUS, GPE0_STATUS_LO/HI) is a LIVE MIRROR of a sticky bit owned by
 *   pm_acpi_core: sw=rw, hw=w, precedence=sw, onwrite=woclr, swmod, reset 0.
 *   `hwset` was REMOVED. hwset ignores `next` entirely, so a multi-bit hwset
 *   set ALL bits of GPE0_STATUS at once, and the else-branch reloaded an
 *   undriven `next` every other cycle, so single-bit status could not hold
 *   state at all. pm_acpi_config_regs decodes the W1C mask (write data AND
 *   byte enables) at the register's own address and hands pm_acpi_core one
 *   per-bit clear pulse per transaction; the core applies
 *   (value & ~clear) | set, so a hardware set wins a same-cycle race.
 * - Self-clearing request bits (ACPI_CONTROL.soft_reset,
 *   PM1_CONTROL.sleep_enable, RESET_CTRL.sys_reset/periph_reset) are
 *   `singlepulse` instead of hw=rw with the wrapper tying `next` to 0. The old
 *   shape reached the same behaviour by accident and hid it in the wrapper.
 * - ACPI_CONTROL.low_power_req and PM1_CONTROL.pwrbtn_ovr/slpbtn_ovr are
 *   documented STORAGE ONLY; they are no longer routed to unused core inputs.
 *
 * Address Layout:
 *   0x000: ACPI_CONTROL        - Global control and power state
 *   0x004: ACPI_STATUS         - Global status and power events (W1C)
 *   0x008: ACPI_INT_ENABLE     - Interrupt enable mask
 *   0x00C: ACPI_INT_STATUS     - Interrupt status (W1C)
 *   0x010: PM1_CONTROL         - PM1 control (sleep, power button)
 *   0x014: PM1_STATUS          - PM1 status flags (W1C)
 *   0x018: PM1_ENABLE          - PM1 event enable mask
 *   0x01C: (Reserved)
 *   0x020: PM_TIMER_VALUE      - PM Timer current value (read-only)
 *   0x024: PM_TIMER_CONFIG     - PM Timer configuration
 *   0x028: (Reserved)
 *   0x02C: (Reserved)
 *   0x030: GPE0_STATUS_LO      - GPE0 status [15:0] (W1C)
 *   0x034: GPE0_STATUS_HI      - GPE0 status [31:16] (W1C)
 *   0x038: GPE0_ENABLE_LO      - GPE0 enable [15:0]
 *   0x03C: GPE0_ENABLE_HI      - GPE0 enable [31:16]
 *   0x040-0x04F: (Reserved for additional GPE banks)
 *   0x050: CLOCK_GATE_CTRL_0   - Clock gate control [31:0]
 *   0x054: CLOCK_GATE_STATUS   - Clock gate status (read-only)
 *   0x058: POWER_DOMAIN_CTRL   - Power domain control [7:0]
 *   0x05C: POWER_DOMAIN_STATUS - Power domain status (read-only)
 *   0x060: WAKE_STATUS         - Wake event sources (W1C)
 *   0x064: WAKE_ENABLE         - Wake event enable mask
 *   0x068: RESET_CTRL          - Reset generation control
 *   0x06C: RESET_STATUS        - Reset status (read-only)
 *   0x070-0xFFF: Reserved for future expansion
 */

addrmap pm_acpi_regs {
    name = "PM_ACPI Power Management Registers";
    desc = "ACPI-compatible power management controller with clock gating and GPE support";

    // Default properties for all registers
    default regwidth = 32;
    default accesswidth = 32;
    default addressing = compact;

    //========================================================================
    // ACPI Control Register (0x000)
    //========================================================================

    reg {
        name = "ACPI Control Register";
        desc = "Global ACPI power management control";

        field {
            name = "ACPI Enable";
            desc = "This block's SCI_EN. Gates GPE event CAPTURE and the
                    pm_interrupt PIN: with it clear the pin is held low. It
                    does NOT gate PM1 or WAKE status recording, so events that
                    happen while ACPI is disabled are still there to read once
                    it is enabled.";
            sw = rw;
            hw = r;
        } acpi_enable[0:0] = 1'b0;

        field {
            name = "PM Timer Enable";
            desc = "Enable PM Timer (0=stopped, 1=running)";
            sw = rw;
            hw = r;
        } pm_timer_enable[1:1] = 1'b0;

        field {
            name = "GPE Enable";
            desc = "Enable GPE event processing";
            sw = rw;
            hw = r;
        } gpe_enable[2:2] = 1'b0;

        field {
            name = "Current Power State";
            desc = "Current power state, as a two-bit ENCODING rather than
                    the ACPI number: 0=S0, 1=S1, 2=S5 (soft off), 3=S3.
                    Encoding 2 was the free one; widening the field would have
                    moved bits software already reads.";
            sw = r;
            hw = w;
        } current_state[5:4];

        field {
            name = "Low Power Mode";
            desc = "STORAGE ONLY - no hardware effect (GH#54 H3). The bit is
                    readable and writable and nothing in pm_acpi_core consumes
                    it: there is no separate 'low power mode' distinct from the
                    S1/S3 states, and the RDL never specified one. Sleep entry
                    is requested through PM1_CONTROL.sleep_type + sleep_enable.
                    The field is kept for register-map compatibility and is
                    documented as software scratch rather than being silently
                    routed to an unused core input.";
            sw = rw;
            hw = r;
        } low_power_req[6:6] = 1'b0;

        field {
            name = "Soft Reset";
            desc = "Write 1 to soft-reset the PM controller (self-clearing, so
                    it always reads 0). One pulse clears every sticky status
                    register (ACPI_STATUS, ACPI_INT_STATUS, PM1_STATUS,
                    WAKE_STATUS, GPE0_STATUS_LO/HI), drops the latched wake
                    request, forces the power-state FSM back to S0 and switches
                    RESET_STATUS from por_reset to sw_reset. Configuration
                    registers are NOT affected.";
            sw = rw;
            hw = r;
            singlepulse;
        } soft_reset[7:7] = 1'b0;

        field {
            name = "Reserved";
            desc = "Reserved bits";
            sw = r;
            hw = na;
        } reserved[31:8] = 24'h0;

    } ACPI_CONTROL @ 0x000;

    //========================================================================
    // ACPI Status Register (0x004)
    //========================================================================

    reg {
        name = "ACPI Status Register";
        desc = "Global ACPI status and events (write 1 to clear)";

        field {
            name = "PME Status";
            desc = "Power Management Event occurred (W1C)";
            sw = rw;
            hw = w;          // live mirror of pm_acpi_core's sticky bit
            precedence = sw; // the W1C write wins over the mirror in its cycle
            onwrite = woclr; // software write-1-to-clear
            swmod;           // drift guard for the wrapper's mirrored decode
        } pme_status[0:0] = 1'b0;

        field {
            name = "Wake Status";
            desc = "System woke from low power state (W1C)";
            sw = rw;
            hw = w;          // live mirror of pm_acpi_core's sticky bit
            precedence = sw; // the W1C write wins over the mirror in its cycle
            onwrite = woclr; // software write-1-to-clear
            swmod;           // drift guard for the wrapper's mirrored decode
        } wake_status[1:1] = 1'b0;

        field {
            name = "Timer Overflow";
            desc = "PM Timer overflow occurred (W1C)";
            sw = rw;
            hw = w;          // live mirror of pm_acpi_core's sticky bit
            precedence = sw; // the W1C write wins over the mirror in its cycle
            onwrite = woclr; // software write-1-to-clear
            swmod;           // drift guard for the wrapper's mirrored decode
        } timer_overflow[2:2] = 1'b0;

        field {
            name = "Power State Transition";
            desc = "Power state transition complete (W1C)";
            sw = rw;
            hw = w;          // live mirror of pm_acpi_core's sticky bit
            precedence = sw; // the W1C write wins over the mirror in its cycle
            onwrite = woclr; // software write-1-to-clear
            swmod;           // drift guard for the wrapper's mirrored decode
        } state_transition[3:3] = 1'b0;

        field {
            name = "Timer Match";
            desc = "The PM timer's low word reached PM_TIMER_MATCH. Sticky and
                    W1C like every other status bit here.";
            sw = rw;
            hw = w;
            precedence = sw;
            onwrite = woclr;
        } timer_match[4:4] = 1'b0;

        field {
            name = "Reserved";
            desc = "Reserved bits";
            sw = r;
            hw = na;
        } reserved[31:5] = 27'h0;

    } ACPI_STATUS @ 0x004;

    //========================================================================
    // ACPI Interrupt Enable Register (0x008)
    //========================================================================

    reg {
        name = "ACPI Interrupt Enable Register";
        desc = "Interrupt enable mask for ACPI events";

        field {
            name = "PME Enable";
            desc = "Enable interrupt on PME event";
            sw = rw;
            hw = r;
        } pme_enable[0:0] = 1'b0;

        field {
            name = "Wake Enable";
            desc = "Enable interrupt on wake event";
            sw = rw;
            hw = r;
        } wake_enable[1:1] = 1'b0;

        field {
            name = "Timer Overflow Enable";
            desc = "Enable interrupt on PM timer overflow";
            sw = rw;
            hw = r;
        } timer_ovf_enable[2:2] = 1'b0;

        field {
            name = "State Transition Enable";
            desc = "Enable interrupt on power state transition";
            sw = rw;
            hw = r;
        } state_trans_enable[3:3] = 1'b0;

        field {
            name = "PM1 Event Enable";
            desc = "Enable interrupt on any PM1 event";
            sw = rw;
            hw = r;
        } pm1_enable[4:4] = 1'b0;

        field {
            name = "GPE Enable";
            desc = "Enable interrupt on any GPE event";
            sw = rw;
            hw = r;
        } gpe_int_enable[5:5] = 1'b0;

        field {
            name = "Timer Match Interrupt Enable";
            desc = "Enable the interrupt for ACPI_STATUS.timer_match";
            sw = rw;
            hw = r;
        } timer_match_enable[6:6] = 1'b0;

        field {
            name = "Reserved";
            desc = "Reserved bits";
            sw = r;
            hw = na;
        } reserved[31:7] = 25'h0;

    } ACPI_INT_ENABLE @ 0x008;

    //========================================================================
    // ACPI Interrupt Status Register (0x00C)
    //========================================================================

    reg {
        name = "ACPI Interrupt Status Register";
        desc = "UNCONDITIONAL per-source EVENT LOG (write 1 to clear). Every
                bit records its event whether or not the matching
                ACPI_INT_ENABLE bit is set, and each clears independently.
                This register does NOT drive the pm_interrupt pin - that is
                the OR of ENABLED bits in ACPI_STATUS, PM1_STATUS and
                GPE0_STATUS - so clearing an interrupt does not mean clearing
                two registers. Read it to find out WHAT happened; clear the
                status register to make the pin drop.";

        field {
            name = "PME Interrupt";
            desc = "PME event recorded (W1C). Set by a power/sleep button press, a wake event or a completed power-state transition.";
            sw = rw;
            hw = w;          // live mirror of pm_acpi_core's sticky bit
            precedence = sw; // the W1C write wins over the mirror in its cycle
            onwrite = woclr; // software write-1-to-clear
            swmod;           // drift guard for the wrapper's mirrored decode
        } pme_int[0:0] = 1'b0;

        field {
            name = "Wake Interrupt";
            desc = "Wake event recorded (W1C). Set by any enabled wake source.";
            sw = rw;
            hw = w;          // live mirror of pm_acpi_core's sticky bit
            precedence = sw; // the W1C write wins over the mirror in its cycle
            onwrite = woclr; // software write-1-to-clear
            swmod;           // drift guard for the wrapper's mirrored decode
        } wake_int[1:1] = 1'b0;

        field {
            name = "Timer Overflow Interrupt";
            desc = "PM timer overflow event recorded (W1C).";
            sw = rw;
            hw = w;          // live mirror of pm_acpi_core's sticky bit
            precedence = sw; // the W1C write wins over the mirror in its cycle
            onwrite = woclr; // software write-1-to-clear
            swmod;           // drift guard for the wrapper's mirrored decode
        } timer_ovf_int[2:2] = 1'b0;

        field {
            name = "State Transition Interrupt";
            desc = "Power-state transition event recorded (W1C).";
            sw = rw;
            hw = w;          // live mirror of pm_acpi_core's sticky bit
            precedence = sw; // the W1C write wins over the mirror in its cycle
            onwrite = woclr; // software write-1-to-clear
            swmod;           // drift guard for the wrapper's mirrored decode
        } state_trans_int[3:3] = 1'b0;

        field {
            name = "PM1 Interrupt";
            desc = "PM1 event recorded (W1C). Set by any of the five PM1_STATUS sources - the SAME sources the PM1 interrupt term uses - regardless of PM1_ENABLE.";
            sw = rw;
            hw = w;          // live mirror of pm_acpi_core's sticky bit
            precedence = sw; // the W1C write wins over the mirror in its cycle
            onwrite = woclr; // software write-1-to-clear
            swmod;           // drift guard for the wrapper's mirrored decode
        } pm1_int[4:4] = 1'b0;

        field {
            name = "GPE Interrupt";
            desc = "GPE event recorded (W1C). Set by a captured GPE EDGE, not by the pending level, so it can be dismissed before GPE0_STATUS_LO/HI is drained. Independent of the GPE0_ENABLE mask; it does follow GPE capture being enabled at all (ACPI_CONTROL.acpi_enable and .gpe_enable), because a GPE this block was told not to watch is not an event it observed.";
            sw = rw;
            hw = w;          // live mirror of pm_acpi_core's sticky bit
            precedence = sw; // the W1C write wins over the mirror in its cycle
            onwrite = woclr; // software write-1-to-clear
            swmod;           // drift guard for the wrapper's mirrored decode
        } gpe_int[5:5] = 1'b0;

        field {
            name = "Timer Match Event";
            desc = "Event log for the timer match, set whatever
                    ACPI_INT_ENABLE.timer_match_enable says";
            sw = rw;
            hw = w;
            precedence = sw;
            onwrite = woclr;
        } timer_match_int[6:6] = 1'b0;

        field {
            name = "Reserved";
            desc = "Reserved bits";
            sw = r;
            hw = na;
        } reserved[31:7] = 25'h0;

    } ACPI_INT_STATUS @ 0x00C;

    //========================================================================
    // PM1 Control Register (0x010)
    //========================================================================

    reg {
        name = "PM1 Control Register";
        desc = "ACPI PM1 control register (sleep, power button)";

        field {
            name = "Sleep Type";
            desc = "Sleep type: 0=S0, 1=S1, 3=S3, 5=S5 (soft off).
                    S5 gates every clock and powers down every domain but
                    the always-on one, like S3, but retains nothing:
                    leaving it pulses sys_reset_req, because a wake from
                    soft off is a boot rather than a resume. Other values
                    are treated as 0 and stay in S0.";
            sw = rw;
            hw = r;
        } sleep_type[2:0] = 3'h0;

        field {
            name = "Sleep Enable";
            desc = "Write 1 to request entry to the state selected by
                    sleep_type. This is a ONE-SHOT request (self-clearing, so it
                    always reads 0) and pm_acpi_core rising-edge detects it, so
                    a wake event that returns the machine to S0 cannot be undone
                    by the still-programmed sleep_type: software does not have
                    to rewrite sleep_type after a wake (GH#54 H5).
                    Corner: a wake landing in the EXACT cycle of this write is
                    not latched - it is still recorded in ACPI_STATUS,
                    PM1_STATUS and WAKE_STATUS and still raises pm_interrupt if
                    enabled, but the machine sleeps and the NEXT wake returns
                    it to S0.";
            sw = rw;
            hw = r;
            singlepulse;
        } sleep_enable[3:3] = 1'b0;

        field {
            name = "Power Button Override";
            desc = "ENABLES the power-button override (RLB-009): with this
                    set, holding the debounced power button for
                    2^BUTTON_TIMING.long_press_shift core-clock cycles forces
                    the machine to S5 (soft off), which is ACPI's four-second
                    override. It enables rather than commands - a control bit
                    that forced soft off would park the machine in S5 on any
                    write that happened to set it. Clearing it turns the escape
                    hatch off. The power button always sets
                    PM1_STATUS.pwrbtn_sts either way; mask its interrupt with
                    PM1_ENABLE.pwrbtn_en and its wake with
                    WAKE_ENABLE.pwrbtn_wake_en.";
            sw = rw;
            hw = r;
        } pwrbtn_ovr[4:4] = 1'b0;

        field {
            name = "Sleep Button Override";
            desc = "STORAGE ONLY - no hardware effect (GH#54 H3), for the same
                    reason as pwrbtn_ovr. Mask the sleep button's interrupt with
                    PM1_ENABLE.slpbtn_en.";
            sw = rw;
            hw = r;
        } slpbtn_ovr[5:5] = 1'b0;

        field {
            name = "Reserved";
            desc = "Reserved bits";
            sw = r;
            hw = na;
        } reserved[31:7] = 25'h0;

    } PM1_CONTROL @ 0x010;

    //========================================================================
    // PM1 Status Register (0x014)
    //========================================================================

    reg {
        name = "PM1 Status Register";
        desc = "ACPI PM1 status flags (write 1 to clear)";

        field {
            name = "Timer Status";
            desc = "PM Timer carry/overflow (W1C)";
            sw = rw;
            hw = w;          // live mirror of pm_acpi_core's sticky bit
            precedence = sw; // the W1C write wins over the mirror in its cycle
            onwrite = woclr; // software write-1-to-clear
            swmod;           // drift guard for the wrapper's mirrored decode
        } tmr_sts[0:0] = 1'b0;

        field {
            name = "Power Button Status";
            desc = "Power button pressed (W1C)";
            sw = rw;
            hw = w;          // live mirror of pm_acpi_core's sticky bit
            precedence = sw; // the W1C write wins over the mirror in its cycle
            onwrite = woclr; // software write-1-to-clear
            swmod;           // drift guard for the wrapper's mirrored decode
        } pwrbtn_sts[1:1] = 1'b0;

        field {
            name = "Sleep Button Status";
            desc = "Sleep button pressed (W1C)";
            sw = rw;
            hw = w;          // live mirror of pm_acpi_core's sticky bit
            precedence = sw; // the W1C write wins over the mirror in its cycle
            onwrite = woclr; // software write-1-to-clear
            swmod;           // drift guard for the wrapper's mirrored decode
        } slpbtn_sts[2:2] = 1'b0;

        field {
            name = "RTC Alarm Status";
            desc = "RTC alarm occurred (W1C). Set on the synchronized rtc_alarm
                    ASSERTION EDGE, not the level, so a W1C clears it even
                    while the pin is still held; the pin must deassert and
                    reassert to record another alarm.";
            sw = rw;
            hw = w;          // live mirror of pm_acpi_core's sticky bit
            precedence = sw; // the W1C write wins over the mirror in its cycle
            onwrite = woclr; // software write-1-to-clear
            swmod;           // drift guard for the wrapper's mirrored decode
        } rtc_sts[3:3] = 1'b0;

        field {
            name = "Wake Status";
            desc = "System wake event (W1C)";
            sw = rw;
            hw = w;          // live mirror of pm_acpi_core's sticky bit
            precedence = sw; // the W1C write wins over the mirror in its cycle
            onwrite = woclr; // software write-1-to-clear
            swmod;           // drift guard for the wrapper's mirrored decode
        } wak_sts[4:4] = 1'b0;

        field {
            name = "Reserved";
            desc = "Reserved bits";
            sw = r;
            hw = na;
        } reserved[31:5] = 27'h0;

    } PM1_STATUS @ 0x014;

    //========================================================================
    // PM1 Enable Register (0x018)
    //========================================================================

    reg {
        name = "PM1 Enable Register";
        desc = "PM1 event enable mask. Each bit gates its source's contribution
                to pm_interrupt; PM1_STATUS still records the event either way
                (GH#54 H3 - before the fix these bits were routed to
                pm_acpi_core and never used). PM1_STATUS.wak_sts has no enable
                bit, matching ACPI: a wake is reported but is not an interrupt
                source on its own.";

        field {
            name = "Timer Enable";
            desc = "Enable PM timer events";
            sw = rw;
            hw = r;
        } tmr_en[0:0] = 1'b0;

        field {
            name = "Power Button Enable";
            desc = "Enable power button events";
            sw = rw;
            hw = r;
        } pwrbtn_en[1:1] = 1'b0;

        field {
            name = "Sleep Button Enable";
            desc = "Enable sleep button events";
            sw = rw;
            hw = r;
        } slpbtn_en[2:2] = 1'b0;

        field {
            name = "RTC Alarm Enable";
            desc = "Enable RTC alarm events";
            sw = rw;
            hw = r;
        } rtc_en[3:3] = 1'b0;

        field {
            name = "Reserved";
            desc = "Reserved bits";
            sw = r;
            hw = na;
        } reserved[31:4] = 28'h0;

    } PM1_ENABLE @ 0x018;

    //========================================================================
    // PM Timer Value Register (0x020)
    //========================================================================

    reg {
        name = "PM Timer Value Register";
        desc = "PM Timer current value (read-only, increments at 3.579545 MHz equivalent)";

        field {
            name = "Timer Value";
            desc = "Current PM timer count value";
            sw = r;
            hw = w;
        } timer_value[31:0];

    } PM_TIMER_VALUE @ 0x020;

    //========================================================================
    // PM Timer Configuration Register (0x024)
    //========================================================================

    reg {
        name = "PM Timer Configuration Register";
        desc = "PM Timer divider and control";

        field {
            name = "Timer Divider";
            desc = "Clock divider for PM timer: timer_clk = sys_clk / (divider + 1)";
            sw = rw;
            hw = r;
        } timer_div[15:0] = 16'd27;  // Default ~3.58MHz @ 100MHz sysclk

        field {
            name = "Timer Prescale";
            desc = "Pre-divide the core clock by 2^this before the divider, so
                    the reachable range is not limited by the divider's 16
                    bits. 0 is no prescaling and is the previous behaviour.";
            sw = rw;
            hw = r;
        } timer_prescale[19:16] = 4'd0;

        field {
            name = "Timer 64-bit Mode";
            desc = "1 = the counter is 64 bits and the overflow event is its
                    carry out of bit 63; 0 = 32 bits, carry out of bit 31. The
                    upper word is always maintained and readable at
                    PM_TIMER_VALUE_HI; this bit only chooses which carry counts
                    as an overflow.";
            sw = rw;
            hw = r;
        } timer_64bit[20:20] = 1'b0;

        field {
            name = "Reserved";
            desc = "Reserved bits";
            sw = r;
            hw = na;
        } reserved[31:21] = 11'h0;

    } PM_TIMER_CONFIG @ 0x024;

    //========================================================================
    // GPE0 Status Low Register (0x030)
    //========================================================================

    reg {
        name = "GPE0 Status Low Register";
        desc = "GPE0 status bits [15:0] (write 1 to clear)";

        field {
            name = "GPE Status [15:0]";
            desc = "General Purpose Event status bits 0-15 (W1C)";
            sw = rw;
            hw = w;          // live mirror of pm_acpi_core's sticky bit
            precedence = sw; // the W1C write wins over the mirror in its cycle
            onwrite = woclr; // software write-1-to-clear
            swmod;           // drift guard for the wrapper's mirrored decode
        } gpe_status[15:0] = 16'h0;

        field {
            name = "Reserved";
            desc = "Reserved bits";
            sw = r;
            hw = na;
        } reserved[31:16] = 16'h0;

    } GPE0_STATUS_LO @ 0x030;

    //========================================================================
    // GPE0 Status High Register (0x034)
    //========================================================================

    reg {
        name = "GPE0 Status High Register";
        desc = "GPE0 status bits [31:16] (write 1 to clear)";

        field {
            name = "GPE Status [31:16]";
            desc = "General Purpose Event status bits 16-31 (W1C)";
            sw = rw;
            hw = w;          // live mirror of pm_acpi_core's sticky bit
            precedence = sw; // the W1C write wins over the mirror in its cycle
            onwrite = woclr; // software write-1-to-clear
            swmod;           // drift guard for the wrapper's mirrored decode
        } gpe_status[15:0] = 16'h0;

        field {
            name = "Reserved";
            desc = "Reserved bits";
            sw = r;
            hw = na;
        } reserved[31:16] = 16'h0;

    } GPE0_STATUS_HI @ 0x034;

    //========================================================================
    // GPE0 Enable Low Register (0x038)
    //========================================================================

    reg {
        name = "GPE0 Enable Low Register";
        desc = "GPE0 enable mask [15:0]";

        field {
            name = "GPE Enable [15:0]";
            desc = "General Purpose Event enable bits 0-15";
            sw = rw;
            hw = r;
        } gpe_enable[15:0] = 16'h0;

        field {
            name = "Reserved";
            desc = "Reserved bits";
            sw = r;
            hw = na;
        } reserved[31:16] = 16'h0;

    } GPE0_ENABLE_LO @ 0x038;

    //========================================================================
    // GPE0 Enable High Register (0x03C)
    //========================================================================

    reg {
        name = "GPE0 Enable High Register";
        desc = "GPE0 enable mask [31:16]";

        field {
            name = "GPE Enable [31:16]";
            desc = "General Purpose Event enable bits 16-31";
            sw = rw;
            hw = r;
        } gpe_enable[15:0] = 16'h0;

        field {
            name = "Reserved";
            desc = "Reserved bits";
            sw = r;
            hw = na;
        } reserved[31:16] = 16'h0;

    } GPE0_ENABLE_HI @ 0x03C;

    //========================================================================
    // Clock Gate Control Register (0x050)
    //========================================================================

    reg {
        name = "Clock Gate Control Register";
        desc = "Clock gating control for system blocks [31:0]";

        field {
            name = "Clock Gate Control";
            desc = "Clock gate enable per block (0=gated/off, 1=enabled/on)";
            sw = rw;
            hw = r;
        } clk_gate_ctrl[31:0] = 32'hFFFFFFFF;  // Default all clocks enabled

    } CLOCK_GATE_CTRL @ 0x050;

    //========================================================================
    // Clock Gate Status Register (0x054)
    //========================================================================

    reg {
        name = "Clock Gate Status Register";
        desc = "Clock gate status (read-only, reflects actual gate state)";

        field {
            name = "Clock Gate Status";
            desc = "Actual clock gate state per block (0=gated, 1=active)";
            sw = r;
            hw = w;
        } clk_gate_status[31:0];

    } CLOCK_GATE_STATUS @ 0x054;

    //========================================================================
    // Power Domain Control Register (0x058)
    //========================================================================

    reg {
        name = "Power Domain Control Register";
        desc = "Power domain enable control [7:0]";

        field {
            name = "Power Domain Control";
            desc = "Power domain enable per domain (0=off, 1=on)";
            sw = rw;
            hw = r;
        } pwr_domain_ctrl[7:0] = 8'hFF;  // Default all domains powered

        field {
            name = "Reserved";
            desc = "Reserved bits";
            sw = r;
            hw = na;
        } reserved[31:8] = 24'h0;

    } POWER_DOMAIN_CTRL @ 0x058;

    //========================================================================
    // Power Domain Status Register (0x05C)
    //========================================================================

    reg {
        name = "Power Domain Status Register";
        desc = "Power domain status (read-only)";

        field {
            name = "Power Domain Status";
            desc = "Actual power domain state (0=off, 1=on)";
            sw = r;
            hw = w;
        } pwr_domain_status[7:0];

        field {
            name = "Reserved";
            desc = "Reserved bits";
            sw = r;
            hw = na;
        } reserved[31:8] = 24'h0;

    } POWER_DOMAIN_STATUS @ 0x05C;

    //========================================================================
    // Wake Status Register (0x060)
    //========================================================================

    reg {
        name = "Wake Status Register";
        desc = "Wake event sources (write 1 to clear)";

        field {
            name = "GPE Wake";
            desc = "Woke from GPE event (W1C)";
            sw = rw;
            hw = w;          // live mirror of pm_acpi_core's sticky bit
            precedence = sw; // the W1C write wins over the mirror in its cycle
            onwrite = woclr; // software write-1-to-clear
            swmod;           // drift guard for the wrapper's mirrored decode
        } gpe_wake[0:0] = 1'b0;

        field {
            name = "Power Button Wake";
            desc = "Woke from power button (W1C)";
            sw = rw;
            hw = w;          // live mirror of pm_acpi_core's sticky bit
            precedence = sw; // the W1C write wins over the mirror in its cycle
            onwrite = woclr; // software write-1-to-clear
            swmod;           // drift guard for the wrapper's mirrored decode
        } pwrbtn_wake[1:1] = 1'b0;

        field {
            name = "RTC Wake";
            desc = "RTC alarm wake source asserted (W1C). Edge-set, like
                    PM1_STATUS.rtc_sts.";
            sw = rw;
            hw = w;          // live mirror of pm_acpi_core's sticky bit
            precedence = sw; // the W1C write wins over the mirror in its cycle
            onwrite = woclr; // software write-1-to-clear
            swmod;           // drift guard for the wrapper's mirrored decode
        } rtc_wake[2:2] = 1'b0;

        field {
            name = "External Wake";
            desc = "External wake source asserted (W1C). Set on the
                    synchronized ext_wake_n ASSERTION EDGE, not the level, so a
                    W1C clears it even while the pin is still held low.";
            sw = rw;
            hw = w;          // live mirror of pm_acpi_core's sticky bit
            precedence = sw; // the W1C write wins over the mirror in its cycle
            onwrite = woclr; // software write-1-to-clear
            swmod;           // drift guard for the wrapper's mirrored decode
        } ext_wake[3:3] = 1'b0;

        field {
            name = "Reserved";
            desc = "Reserved bits";
            sw = r;
            hw = na;
        } reserved[31:4] = 28'h0;

    } WAKE_STATUS @ 0x060;

    //========================================================================
    // Wake Enable Register (0x064)
    //========================================================================

    reg {
        name = "Wake Enable Register";
        desc = "Wake event enable mask";

        field {
            name = "GPE Wake Enable";
            desc = "Enable wake from GPE events";
            sw = rw;
            hw = r;
        } gpe_wake_en[0:0] = 1'b0;

        field {
            name = "Power Button Wake Enable";
            desc = "Enable wake from power button";
            sw = rw;
            hw = r;
        } pwrbtn_wake_en[1:1] = 1'b0;

        field {
            name = "RTC Wake Enable";
            desc = "Enable wake from RTC alarm";
            sw = rw;
            hw = r;
        } rtc_wake_en[2:2] = 1'b0;

        field {
            name = "External Wake Enable";
            desc = "Enable wake from external signal";
            sw = rw;
            hw = r;
        } ext_wake_en[3:3] = 1'b0;

        field {
            name = "Reserved";
            desc = "Reserved bits";
            sw = r;
            hw = na;
        } reserved[31:4] = 28'h0;

    } WAKE_ENABLE @ 0x064;

    //========================================================================
    // Reset Control Register (0x068)
    //========================================================================

    reg {
        name = "Reset Control Register";
        desc = "Reset generation and control";

        field {
            name = "System Reset";
            desc = "Write 1 to pulse the sys_reset_req output for one PM-clock
                    cycle (self-clearing, so it always reads 0). What the system
                    does with that request is outside this block.";
            sw = rw;
            hw = r;
            singlepulse;
        } sys_reset[0:0] = 1'b0;

        field {
            name = "Peripheral Reset";
            desc = "Write 1 to pulse the periph_reset_req output for one
                    PM-clock cycle (self-clearing, so it always reads 0).";
            sw = rw;
            hw = r;
            singlepulse;
        } periph_reset[1:1] = 1'b0;

        field {
            name = "Reserved";
            desc = "Reserved bits";
            sw = r;
            hw = na;
        } reserved[31:2] = 30'h0;

    } RESET_CTRL @ 0x068;

    //========================================================================
    // Reset Status Register (0x06C)
    //========================================================================

    reg {
        name = "Reset Status Register";
        desc = "Reset source information (read-only)";

        field {
            name = "Power-On Reset";
            desc = "Reads 1 while the last reset of this block was the
                    power-on/system reset (a STICKY LEVEL, not the one-cycle
                    pulse it used to be - software could never observe that
                    through APB latency, GH#54 round_2 item 7). Cleared only
                    when ACPI_CONTROL.soft_reset executes, which hands the
                    'last reset' title to sw_reset.";
            sw = r;
            hw = w;
        } por_reset[0:0];

        field {
            name = "Watchdog Reset";
            desc = "ALWAYS READS 0 - apb4_pm_acpi has no watchdog input port, so
                    a watchdog reset is not observable here (GH#54 round_2 item
                    7). Kept for register-map compatibility; wiring it would
                    take a new device pin.";
            sw = r;
            hw = w;
        } wdt_reset[1:1];

        field {
            name = "Software Reset";
            desc = "Reads 1 once ACPI_CONTROL.soft_reset has been executed at
                    least since the last hardware reset (sticky level; por_reset
                    drops in the same cycle).";
            sw = r;
            hw = w;
        } sw_reset[2:2];

        field {
            name = "External Reset";
            desc = "ALWAYS READS 0 - apb4_pm_acpi has no external-reset input
                    port, so an external reset is indistinguishable from a
                    power-on reset here (GH#54 round_2 item 7).";
            sw = r;
            hw = w;
        } ext_reset[3:3];

        field {
            name = "Reserved";
            desc = "Reserved bits";
            sw = r;
            hw = na;
        } reserved[31:4] = 28'h0;

    } RESET_STATUS @ 0x06C;

    reg {
        name = "Button Timing";
        desc = "Debounce and long-press thresholds for the two buttons, in
                core-clock cycles. The buttons used to get a plain three-flop
                synchronizer, which resolves metastability but does nothing
                about contact bounce: a single press could be recorded as
                several (RLB-009).";

        field {
            name = "Debounce Cycles";
            desc = "The button level must be STABLE for this many core-clock
                    cycles before an edge is reported. RESETS TO 0, which is no
                    debouncing and exactly the previous behaviour: a feature
                    that changed what the block does out of reset would be a
                    behaviour change wearing a feature's clothes. A mechanical
                    push button wants something around 10 ms, which is
                    1,000,000 at 100 MHz.";
            sw = rw;
            hw = r;
        } debounce_cycles[23:0] = 24'd0;

        field {
            name = "Long Press Shift";
            desc = "Long-press threshold as a power of two: holding the
                    DEBOUNCED power button for 2^this core-clock cycles asserts
                    the override and forces the machine to S5 (soft off), which
                    is what ACPI's four-second power-button override does. At
                    100 MHz the reset default of 28 is about 2.7 seconds; 29 is
                    about 5.4. 0 disables the override.";
            sw = rw;
            hw = r;
        } long_press_shift[28:24] = 5'd28;

    } BUTTON_TIMING @ 0x070;

    reg {
        name = "PM Timer Value High";
        desc = "Upper word of the 64-bit PM timer.

                READ PM_TIMER_VALUE FIRST. That read latches this word, so the
                pair software gets is one coherent 64-bit sample. Reading the
                halves independently of a running counter can straddle a carry
                and produce a value the timer never held.";

        field {
            name = "Timer Value High";
            desc = "Bits [63:32] of the counter, as latched by the last read of
                    PM_TIMER_VALUE";
            sw = r;
            hw = w;
        } value_hi[31:0] = 32'h0;

    } PM_TIMER_VALUE_HI @ 0x074;

    reg {
        name = "PM Timer Match";
        desc = "Compare value for the PM timer's LOW word. When the counter
                reaches it, ACPI_STATUS.timer_match sets and, if
                ACPI_INT_ENABLE.timer_match_enable is set, the interrupt
                asserts. The comparison is on the low 32 bits whatever
                PM_TIMER_CONFIG.timer_64bit says.";

        field {
            name = "Match Value";
            desc = "Compare value";
            sw = rw;
            hw = r;
        } match_value[31:0] = 32'h0;

    } PM_TIMER_MATCH @ 0x078;

};
