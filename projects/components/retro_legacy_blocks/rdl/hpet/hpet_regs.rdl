/**
 * SystemRDL Definition for HPET Configuration Registers - Version 2
 *
 * This version generates hwif signals that directly match the existing
 * hpet_config_regs.sv interface, avoiding the need for complex signal mapping.
 *
 * Key changes from v1:
 * - Removed 'external' keyword from TIMER registers
 * - All registers now generate hardware interface signals
 * - Signal names designed to match existing RTL interface
 *
 * Address Layout:
 *   0x000-0x0FF: Global registers
 *   0x100-0x1FF: Timer registers (32 bytes per timer)
 *   0x200-0xFFF: Reserved for future expansion
 *
 * Updated 2026-09-08 - issue #46:
 *   - HPET_STATUS.timer_int_status is a plain W1C MIRROR of hpet_core's
 *     r_interrupt_status (sw=rw, hw=w, onwrite=woclr, precedence=sw, reset 0).
 *     The sticky/hwset properties were REMOVED: PeakRDL renders a multi-bit
 *     sticky field as "load `next` only while the register reads all-zero,
 *     otherwise set ALL bits on hwset", which set 8'hFF whenever a second
 *     timer fired with an earlier bit still pending (C2), and the field had
 *     no reset branch at all (round_2 H1). The core owns the state; this
 *     register only reflects it.
 *   - TIMER_COMPARATOR_LO/HI carry `swmod` so the wrapper can drive
 *     hpet_core from the WRITE STROBE instead of from a change in the stored
 *     value (round_3 Low: rewriting the same comparator produced no strobe).
 *   - HPET_ID.vendor_id/rev_id are hw=w and driven from the SystemVerilog
 *     VENDOR_ID/REVISION_ID parameters instead of being frozen at generation
 *     time; leg_rt_cap now reports 0 (see the field descriptions).
 */

addrmap hpet_regs #(
    longint VENDOR_ID = 1,      // Vendor ID parameter
    longint REVISION_ID = 1,    // Revision ID parameter
    longint NUM_TIMERS = 8      // Number of timers (2-8), generate with maximum
) {
    name = "HPET Configuration Registers";
    desc = "High Precision Event Timer configuration and status registers";

    // Default properties for all registers
    default regwidth = 32;
    default accesswidth = 32;
    default addressing = compact;

    //========================================================================
    // Global Registers (0x000-0x0FF)
    //========================================================================

    reg {
        name = "HPET Identification Register";
        desc = "Contains vendor ID, revision, and capability information";

        field {
            name = "Reserved";
            desc = "Reserved bits";
            sw = r;
            hw = na;
        } reserved_low[4:0] = 5'h0;

        field {
            name = "Legacy Replacement Capable";
            desc = "Reports 0: this implementation has NO legacy replacement
                    routing. HPET_CONFIG.legacy_replacement is storage that
                    reaches no hardware, so advertising the capability here
                    would be a lie a driver could act on. Set this to 1 only
                    when the routing is actually implemented.";
            sw = r;
            hw = na;
        } leg_rt_cap[5:5] = 1'b0;

        field {
            name = "Reserved";
            desc = "Reserved bit";
            sw = r;
            hw = na;
        } reserved_mid[6:6] = 1'b0;

        field {
            name = "Counter Size";
            desc = "1 = 64-bit counter capable";
            sw = r;
            hw = na;
        } count_size_cap[7:7] = 1'b1;

        field {
            name = "Number of Timers";
            desc = "Number of timers minus 1 (N-1)";
            sw = r;
            hw = w;
            reset = NUM_TIMERS - 1;
        } num_tim_cap[12:8];

        field {
            name = "Reserved";
            desc = "Reserved bits";
            sw = r;
            hw = na;
        } reserved_upper[15:13] = 3'h0;

        field {
            name = "Revision ID";
            desc = "Implementation revision identifier. Driven from the
                    hpet_config_regs REVISION_ID parameter (low 8 bits) so a
                    single generated regblock serves every instantiation.";
            sw = r;
            hw = w;
            reset = REVISION_ID;
        } rev_id[23:16];

        field {
            name = "Vendor ID";
            desc = "Vendor identifier. Driven from the hpet_config_regs
                    VENDOR_ID parameter (low 8 bits). NOTE: this field is 8
                    bits wide, unlike the 16-bit vendor field of the real
                    HPET GCAP_ID, so a wider parameter reads back truncated
                    (e.g. VENDOR_ID=0x8086 reads 0x86).";
            sw = r;
            hw = w;
            reset = VENDOR_ID;
        } vendor_id[31:24];

    } HPET_ID @ 0x000;

    reg {
        name = "HPET Configuration Register";
        desc = "Global configuration and control";

        field {
            name = "Enable";
            desc = "Enable main counter";
            sw = rw;
            hw = r;
        } hpet_enable[0:0] = 1'b0;

        field {
            name = "Legacy Replacement Route";
            desc = "Enable legacy replacement mode";
            sw = rw;
            hw = r;
        } legacy_replacement[1:1] = 1'b0;

        field {
            name = "Reserved";
            desc = "Reserved bits";
            sw = r;
            hw = na;
        } reserved[31:2] = 30'h0;

    } HPET_CONFIG @ 0x004;

    reg {
        name = "HPET Interrupt Status Register";
        desc = "Interrupt status for all timers";

        field {
            name = "Timer Interrupt Status";
            desc = "Interrupt status bits for each timer (write 1 to clear).
                    Read-only MIRROR of hpet_core's r_interrupt_status, which
                    owns the sticky state; the wrapper drives `next` every
                    cycle and turns the software write into a per-bit
                    timer_int_clear pulse into the core.";
            sw = rw;
            hw = w;          // Hardware writes the core's live status level
            precedence = sw; // The W1C write wins over the mirror in its cycle
            onwrite = woclr; // Software write-1-to-clear
            swmod;           // Drift guard for the wrapper's mirrored decode
        } timer_int_status[NUM_TIMERS-1:0] = 0;

        field {
            name = "Reserved";
            desc = "Reserved bits for unused timers";
            sw = r;
            hw = na;
        } reserved[31:NUM_TIMERS] = 32'h0;

    } HPET_STATUS @ 0x008;

    // Reserved space
    reg {
        name = "Reserved";
        desc = "Reserved register";
        field {
            sw = r;
            hw = na;
        } reserved[31:0] = 32'h0;
    } RESERVED_0C @ 0x00C;

    reg {
        name = "Main Counter Low";
        desc = "Main counter value - low 32 bits";

        field {
            name = "Counter Low";
            desc = "Lower 32 bits of 64-bit main counter";
            sw = rw;
            hw = rw;    // HW writes the live counter in, and reads the field
                        // back out so the wrapper can take the just-written
                        // value (byte strobes already merged) at its strobe
            precedence = sw;  // Software write takes priority
            swmod;      // Write STROBE into hpet_core (issue #46 C3)
        } counter_lo[31:0] = 32'h0;

    } HPET_COUNTER_LO @ 0x010;

    reg {
        name = "Main Counter High";
        desc = "Main counter value - high 32 bits";

        field {
            name = "Counter High";
            desc = "Upper 32 bits of 64-bit main counter";
            sw = rw;
            hw = rw;    // HW writes the live counter in, and reads the field
                        // back out so the wrapper can take the just-written
                        // value (byte strobes already merged) at its strobe
            precedence = sw;  // Software write takes priority
            swmod;      // Write STROBE into hpet_core (issue #46 C3)
        } counter_hi[31:0] = 32'h0;

    } HPET_COUNTER_HI @ 0x014;

    //========================================================================
    // Timer Registers (0x100-0x1FF)
    // Each timer occupies 32 bytes (0x20)
    // NO LONGER USING 'external' - generates normal hwif signals
    //========================================================================

    // Define a timer register block
    regfile timer_regfile {
        name = "HPET Timer Registers";
        desc = "Configuration and comparator registers for one timer";

        reg {
            name = "Timer Configuration Register";
            desc = "Configuration and control for this timer";

            field {
                name = "Reserved";
                desc = "Reserved bits";
                sw = r;
                hw = na;
            } reserved_low[1:0] = 2'b0;

            field {
                name = "Timer Enable";
                desc = "Enable this timer";
                sw = rw;
                hw = r;
            } timer_enable[2:2] = 1'b0;

            field {
                name = "Timer Interrupt Enable";
                desc = "Enable interrupt generation";
                sw = rw;
                hw = r;
            } timer_int_enable[3:3] = 1'b0;

            field {
                name = "Timer Type";
                desc = "0=one-shot, 1=periodic";
                sw = rw;
                hw = r;
            } timer_type[4:4] = 1'b0;

            field {
                name = "Timer Size";
                desc = "0=32-bit, 1=64-bit";
                sw = rw;
                hw = r;
            } timer_size[5:5] = 1'b0;

            field {
                name = "Timer Value Set";
                desc = "NOT IMPLEMENTED. Stored and readable, but no logic
                        consumes it. On a real HPET this selects whether a
                        periodic comparator write loads the accumulator or
                        the period; this core always loads both, so the bit
                        has nothing to select. Kept so the register layout
                        matches the documented map.";
                sw = rw;
                hw = r;
            } timer_value_set[6:6] = 1'b0;

            field {
                name = "Reserved";
                desc = "Reserved bits";
                sw = r;
                hw = na;
            } reserved_high[31:7] = 25'h0;

        } TIMER_CONFIG @ 0x00;

        reg {
            name = "Timer Comparator Low";
            desc = "Timer comparator value - low 32 bits";

            field {
                name = "Comparator Low";
                desc = "Lower 32 bits of 64-bit comparator";
                sw = rw;
                hw = r;
                swmod;      // Write STROBE into hpet_core (issue #46 round_3)
            } timer_comp_lo[31:0] = 32'h0;

        } TIMER_COMPARATOR_LO @ 0x04;

        reg {
            name = "Timer Comparator High";
            desc = "Timer comparator value - high 32 bits";

            field {
                name = "Comparator High";
                desc = "Upper 32 bits of 64-bit comparator";
                sw = rw;
                hw = r;
                swmod;      // Write STROBE into hpet_core (issue #46 round_3)
            } timer_comp_hi[31:0] = 32'h0;

        } TIMER_COMPARATOR_HI @ 0x08;

        reg {
            name = "Reserved";
            desc = "Reserved register";
            field {
                sw = r;
                hw = na;
            } reserved[31:0] = 32'h0;
        } RESERVED @ 0x0C;

    }; // timer_regfile

    // Instantiate timer register blocks for each timer
    // REMOVED 'external' keyword - now generates normal hwif signals
    timer_regfile TIMER[NUM_TIMERS] @ 0x100 += 0x20;

}; // hpet_regs
