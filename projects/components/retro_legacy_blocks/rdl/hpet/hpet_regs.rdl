/**
 * SystemRDL Definition for HPET Configuration Registers - Version 2
 *
 * This version generates hwif signals that directly match the existing
 * hpet_config_regs.sv interface, avoiding the need for complex signal mapping.
 *
 * Key changes from v1:
 * - Removed 'external' keyword from TIMER registers
 * - All registers now generate hardware interface signals
 * - Signal names designed to match existing RTL interface
 *
 * Address Layout:
 *   0x000-0x0FF: Global registers
 *   0x100-0x1FF: Timer registers (32 bytes per timer)
 *   0x200-0xFFF: Reserved for future expansion
 *
 * Updated 2026-09-08 - issue #46:
 *   - HPET_STATUS.timer_int_status is a plain W1C MIRROR of hpet_core's
 *     r_interrupt_status (sw=rw, hw=w, onwrite=woclr, precedence=sw, reset 0).
 *     The sticky/hwset properties were REMOVED: PeakRDL renders a multi-bit
 *     sticky field as "load `next` only while the register reads all-zero,
 *     otherwise set ALL bits on hwset", which set 8'hFF whenever a second
 *     timer fired with an earlier bit still pending (C2), and the field had
 *     no reset branch at all (round_2 H1). The core owns the state; this
 *     register only reflects it.
 *   - TIMER_COMPARATOR_LO/HI carry `swmod` so the wrapper can drive
 *     hpet_core from the WRITE STROBE instead of from a change in the stored
 *     value (round_3 Low: rewriting the same comparator produced no strobe).
 *   - HPET_ID.vendor_id/rev_id are hw=w and driven from the SystemVerilog
 *     VENDOR_ID/REVISION_ID parameters instead of being frozen at generation
 *     time; leg_rt_cap now reports 0 (see the field descriptions).
 */

addrmap hpet_regs #(
    longint VENDOR_ID = 1,      // Vendor ID parameter
    longint REVISION_ID = 1,    // Revision ID parameter
    longint NUM_TIMERS = 8,     // Number of timers (2-8), generate with maximum
    // GCAP_ID[63:32], femtoseconds per main-counter tick. Default 10 ns
    // (100 MHz hpet_clk). Spec: non-zero and <= 0x05F5E100 (100 ns).
    longint COUNTER_CLK_PERIOD_FS = 10000000
) {
    name = "HPET Configuration Registers";
    desc = "High Precision Event Timer configuration and status registers";

    // Default properties for all registers
    default regwidth = 32;
    default accesswidth = 32;
    default addressing = compact;

    //========================================================================
    // Global Registers (0x000-0x0FF)
    //========================================================================

    reg {
        name = "HPET Identification Register";
        desc = "Contains vendor ID, revision, and capability information";

        field {
            name = "Revision ID";
            desc = "GCAP_ID[7:0]. Implementation revision, driven from the
                    REVISION_ID parameter so one generated regblock serves every
                    instantiation.";
            sw = r;
            hw = w;
            reset = REVISION_ID;
        } rev_id[7:0];

        field {
            name = "Number of Timers";
            desc = "GCAP_ID[12:8]. Number of timers MINUS ONE (N-1).";
            sw = r;
            hw = w;
            reset = NUM_TIMERS - 1;
        } num_tim_cap[12:8];

        field {
            name = "Counter Size Capability";
            desc = "GCAP_ID[13]. 1 = the main counter is 64 bits wide.";
            sw = r;
            hw = na;
        } count_size_cap[13:13] = 1'b1;

        field {
            name = "Reserved";
            desc = "GCAP_ID[14].";
            sw = r;
            hw = na;
        } reserved_14[14:14] = 1'b0;

        field {
            name = "Legacy Replacement Capable";
            desc = "GCAP_ID[15]. Reports 0: no legacy replacement routing is
                    implemented, and HPET_CONFIG.legacy_replacement reaches no
                    hardware. This bit position is load-bearing -- real drivers
                    gate on it (FreeBSD: if ((caps & HPET_CAP_LEG_RT) == 0)
                    legacy_route = 0), so a driver reading 0 here will not use
                    legacy mode at all. Set to 1 only when RLB/hpet TASK-003
                    implements the routing.";
            sw = r;
            hw = na;
        } leg_rt_cap[15:15] = 1'b0;

        field {
            name = "Vendor ID";
            desc = "GCAP_ID[31:16]. Sixteen bits, per the spec, driven from the
                    VENDOR_ID parameter -- so a PCI-style vendor such as 0x8086
                    now reads back in full rather than truncated to its low
                    byte.";
            sw = r;
            hw = w;
            reset = VENDOR_ID;
        } vendor_id[31:16];

    } HPET_ID @ 0x000;

    reg {
        name = "HPET Counter Clock Period";
        desc = "GCAP_ID[63:32] -- the main counter tick period in FEMTOSECONDS.
                Not a separate register in the spec: it is the high half of the
                64-bit capability register, which at a 32-bit access width lands
                here at 0x004. Software derives frequency as 1e15 / period.

                Driven from the COUNTER_CLK_PERIOD_FS parameter. The counter
                ticks on CDC_ENABLE[0] ? hpet_clk : pclk, so an instantiation
                MUST pass the period of whichever clock that is -- a wrong value
                makes every software time conversion wrong while the hardware
                looks correct.

                Spec bounds: non-zero, and at most 0x05F5E100 (100_000_000 fs =
                100 ns), i.e. a 10 MHz minimum counter frequency.";

        field {
            name = "Counter Clock Period";
            desc = "Femtoseconds per main-counter tick. HARDWARE-DRIVEN (hw = w),
                    not an RDL reset value: PeakRDL bakes RDL parameters into the
                    generated package as localparams, so one regblock is built
                    for every instantiation and a per-instance period could not
                    come through that path. hpet_config_regs drives it from its
                    own COUNTER_CLK_PERIOD_FS parameter, exactly as it drives
                    num_tim_cap, rev_id and vendor_id.";
            sw = r;
            hw = w;
            reset = COUNTER_CLK_PERIOD_FS;
        } counter_clk_period[31:0];

    } HPET_PERIOD @ 0x004;

    reg {
        name = "HPET Configuration Register";
        desc = "Global configuration and control";

        field {
            name = "Enable";
            desc = "Enable main counter";
            sw = rw;
            hw = r;
        } hpet_enable[0:0] = 1'b0;

        field {
            name = "Legacy Replacement Route";
            desc = "Enable legacy replacement mode";
            sw = rw;
            hw = r;
        } legacy_replacement[1:1] = 1'b0;

        field {
            name = "Reserved";
            desc = "Reserved bits";
            sw = r;
            hw = na;
        } reserved[31:2] = 30'h0;

    } HPET_CONFIG @ 0x010;

    reg {
        name = "HPET Interrupt Status Register";
        desc = "Interrupt status for all timers";

        field {
            name = "Timer Interrupt Status";
            desc = "Interrupt status bits for each timer (write 1 to clear).
                    Read-only MIRROR of hpet_core's r_interrupt_status, which
                    owns the sticky state; the wrapper drives `next` every
                    cycle and turns the software write into a per-bit
                    timer_int_clear pulse into the core.";
            sw = rw;
            hw = w;          // Hardware writes the core's live status level
            precedence = sw; // The W1C write wins over the mirror in its cycle
            onwrite = woclr; // Software write-1-to-clear
            swmod;           // Drift guard for the wrapper's mirrored decode
        } timer_int_status[NUM_TIMERS-1:0] = 0;

        field {
            name = "Reserved";
            desc = "Reserved bits for unused timers";
            sw = r;
            hw = na;
        } reserved[31:NUM_TIMERS] = 32'h0;

    } HPET_STATUS @ 0x020;

    // Reserved space
    
    reg {
        name = "Main Counter Low";
        desc = "Main counter value - low 32 bits";

        field {
            name = "Counter Low";
            desc = "Lower 32 bits of 64-bit main counter";
            sw = rw;
            hw = rw;    // HW writes the live counter in, and reads the field
                        // back out so the wrapper can take the just-written
                        // value (byte strobes already merged) at its strobe
            precedence = sw;  // Software write takes priority
            swmod;      // Write STROBE into hpet_core (issue #46 C3)
        } counter_lo[31:0] = 32'h0;

    } HPET_COUNTER_LO @ 0x0F0;

    reg {
        name = "Main Counter High";
        desc = "Main counter value - high 32 bits";

        field {
            name = "Counter High";
            desc = "Upper 32 bits of 64-bit main counter";
            sw = rw;
            hw = rw;    // HW writes the live counter in, and reads the field
                        // back out so the wrapper can take the just-written
                        // value (byte strobes already merged) at its strobe
            precedence = sw;  // Software write takes priority
            swmod;      // Write STROBE into hpet_core (issue #46 C3)
        } counter_hi[31:0] = 32'h0;

    } HPET_COUNTER_HI @ 0x0F4;

    //========================================================================
    // Timer Registers (0x100-0x1FF)
    // Each timer occupies 32 bytes (0x20)
    // NO LONGER USING 'external' - generates normal hwif signals
    //========================================================================

    // Define a timer register block
    regfile timer_regfile {
        name = "HPET Timer Registers";
        desc = "Configuration and comparator registers for one timer";

        reg {
            name = "Timer Configuration Register";
            desc = "Configuration and control for this timer";

            field {
                name = "Reserved";
                desc = "TN_CONF[0].";
                sw = r;
                hw = na;
            } reserved_0[0:0] = 1'b0;

            field {
                name = "Interrupt Type";
                desc = "TN_CONF[1]. 0 = edge-triggered, 1 = level-triggered.
                        STORAGE ONLY: this core always delivers the sticky
                        level-plus-W1C behaviour HPET_STATUS implements, so
                        nothing consumes the bit. Kept at its spec position so a
                        spec-written driver's write lands where it expects.";
                sw = rw;
                hw = r;
            } timer_int_type[1:1] = 1'b0;

            field {
                name = "Interrupt Enable";
                desc = "TN_CONF[2]. 1 = a match on this timer raises its
                        interrupt. This is the ONLY per-timer enable the spec
                        defines: a timer's comparator is live whenever the main
                        counter runs.";
                sw = rw;
                hw = r;
            } timer_int_enable[2:2] = 1'b0;

            field {
                name = "Timer Type";
                desc = "TN_CONF[3]. 0 = one-shot, 1 = periodic.";
                sw = rw;
                hw = r;
            } timer_type[3:3] = 1'b0;

            field {
                name = "Periodic Interrupt Capability";
                desc = "TN_CONF[4], READ-ONLY. 1 = this timer supports periodic
                        mode. Every timer here does.";
                sw = r;
                hw = na;
            } per_int_cap[4:4] = 1'b1;

            field {
                name = "Size Capability";
                desc = "TN_CONF[5], READ-ONLY. 1 = this timer is 64-bit capable.";
                sw = r;
                hw = na;
            } size_cap[5:5] = 1'b1;

            field {
                name = "Value Set";
                desc = "TN_CONF[6]. NOT IMPLEMENTED -- stored and readable, but
                        no logic consumes it. On a spec HPET this selects whether
                        a periodic comparator write loads the accumulator or the
                        period; this core always loads both, so the bit has
                        nothing to select.";
                sw = rw;
                hw = r;
            } timer_value_set[6:6] = 1'b0;

            field {
                name = "Reserved";
                desc = "TN_CONF[7].";
                sw = r;
                hw = na;
            } reserved_7[7:7] = 1'b0;

            field {
                name = "32-bit Mode";
                desc = "TN_CONF[8]. 1 = FORCE 32-bit operation on this 64-bit
                        timer. NOTE THE POLARITY: the spec's sense is the inverse
                        of the compare-width signal the core takes, so
                        hpet_config_regs drives timer_size = ~timer_32mode.

                        CONTRACT: change this only while the main counter is
                        halted, and rewrite the comparator afterwards. The old
                        width's comparator lattice is not the new width's.";
                sw = rw;
                hw = r;
            } timer_32mode[8:8] = 1'b0;

            field {
                name = "Interrupt Route";
                desc = "TN_CONF[13:9]. Which I/O APIC input this timer drives,
                        as a bit NUMBER selected from TIMER_INT_ROUTE_CAP.
                        STORAGE ONLY until RLB/hpet TASK-003 implements routing;
                        TIMER_INT_ROUTE_CAP reads 0 meanwhile, so a driver that
                        consults the capability first will not pick a route.";
                sw = rw;
                hw = r;
            } timer_int_route[13:9] = 5'h0;

            field {
                name = "FSB Interrupt Enable";
                desc = "TN_CONF[14]. STORAGE ONLY -- FSB (message) delivery is
                        not implemented, which fsb_int_del_cap reports as 0.";
                sw = rw;
                hw = r;
            } timer_fsb_en[14:14] = 1'b0;

            field {
                name = "FSB Interrupt Delivery Capability";
                desc = "TN_CONF[15], READ-ONLY. 0 = no FSB/message delivery, so
                        the spec's optional TN_FSB_VAL/TN_FSB_ADDR registers at
                        +0x10/+0x14 are deliberately not implemented.";
                sw = r;
                hw = na;
            } fsb_int_del_cap[15:15] = 1'b0;

            field {
                name = "Reserved";
                desc = "TN_CONF[31:16].";
                sw = r;
                hw = na;
            } reserved_high[31:16] = 16'h0;

        } TIMER_CONFIG @ 0x00;

        reg {
            name = "Timer Interrupt Route Capability";
            desc = "TN_CONF[63:32]: bitmap of the I/O APIC inputs this timer may
                    be routed to. READS 0 TODAY -- no routing is implemented, so
                    advertising legal routes would be a lie a driver could act
                    on. RLB/hpet TASK-003 sets this alongside
                    HPET_ID.leg_rt_cap when the routing lands. Software selects
                    a route by writing TIMER_CONFIG.timer_int_route with a bit
                    number from this mask.";

            field {
                name = "Interrupt Route Capability";
                desc = "One bit per legal I/O APIC input. 0 = none legal yet.";
                sw = r;
                hw = na;
            } int_route_cap[31:0] = 32'h0;

        } TIMER_INT_ROUTE_CAP @ 0x04;

        reg {
            name = "Timer Comparator Low";
            desc = "Timer comparator value - low 32 bits";

            field {
                name = "Comparator Low";
                desc = "Lower 32 bits of 64-bit comparator.
                        READS RETURN THE LIVE VALUE hpet_core is comparing
                        against, including the periodic auto-advance -- not
                        the last value software wrote (RLB/hpet TASK-002).
                        hw=rw with precedence=sw is what makes both directions
                        work, and is the same idiom HPET_COUNTER_LO/HI use:
                        hardware READS the field to carry a software write down
                        to the core, and WRITES it continuously to publish the
                        live value back, while precedence=sw lets a software
                        write win in its own cycle. The field still holds the
                        committed value during the aligned timer_comp_write_*
                        strobe cycle, which is where the wrapper samples it;
                        hardware resumes mirroring one cycle later.";
                sw = rw;
                hw = rw;    // HW writes the live comparator in, and reads the
                            // field back out so the wrapper can take the
                            // just-written value at its strobe
                precedence = sw;  // Software write takes priority
                swmod;      // Write STROBE into hpet_core (issue #46 round_3)
            } timer_comp_lo[31:0] = 32'h0;

        } TIMER_COMPARATOR_LO @ 0x08;

        reg {
            name = "Timer Comparator High";
            desc = "Timer comparator value - high 32 bits";

            field {
                name = "Comparator High";
                desc = "Upper 32 bits of 64-bit comparator.
                        READS RETURN THE LIVE VALUE hpet_core is comparing
                        against, including the periodic auto-advance -- not
                        the last value software wrote (RLB/hpet TASK-002).
                        hw=rw with precedence=sw is what makes both directions
                        work, and is the same idiom HPET_COUNTER_LO/HI use:
                        hardware READS the field to carry a software write down
                        to the core, and WRITES it continuously to publish the
                        live value back, while precedence=sw lets a software
                        write win in its own cycle. The field still holds the
                        committed value during the aligned timer_comp_write_*
                        strobe cycle, which is where the wrapper samples it;
                        hardware resumes mirroring one cycle later.";
                sw = rw;
                hw = rw;    // HW writes the live comparator in, and reads the
                            // field back out so the wrapper can take the
                            // just-written value at its strobe
                precedence = sw;  // Software write takes priority
                swmod;      // Write STROBE into hpet_core (issue #46 round_3)
            } timer_comp_hi[31:0] = 32'h0;

        } TIMER_COMPARATOR_HI @ 0x0C;

        
    }; // timer_regfile

    // Instantiate timer register blocks for each timer
    // REMOVED 'external' keyword - now generates normal hwif signals
    timer_regfile TIMER[NUM_TIMERS] @ 0x100 += 0x20;

}; // hpet_regs
