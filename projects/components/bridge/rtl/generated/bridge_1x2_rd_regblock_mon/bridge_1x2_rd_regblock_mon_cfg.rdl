// SPDX-License-Identifier: MIT
// SPDX-FileCopyrightText: 2026 sean galloway
//
// bridge_1x2_rd_regblock_mon_cfg — auto-generated bridge monitor cfg space.
//
// Generated by bridge_pkg/generators/cfg_rdl_generator.py from the
// adapter list of bridge_1x2_rd_regblock_mon. Backed by an AXI4-Lite slave
// (cpuif=axi4-lite-flat); the bridge top instantiates the emitted
// regblock and routes hwif_out fields to its internal cfg_* nets.
//
// Field schema mirrors the bridge generator's MONITOR_CFG_SIGNALS
// list (single source of truth in axi4_timing_wrapper_component.py).
// Per-direction register layout:
//
//   +0x00  CTRL     enables[6:0] + timeout_cycles[31:16]
//   +0x04  LATENCY  latency_threshold[31:0]
//   +0x08  MASKS_A  axi_pkt_mask     + axi_err_select
//   +0x0C  MASKS_B  axi_error_mask   + axi_timeout_mask
//   +0x10  MASKS_C  axi_compl_mask   + axi_thresh_mask
//   +0x14  MASKS_D  axi_perf_mask    + axi_addr_mask
//   +0x18  MASKS_E  axi_debug_mask   (upper 16b reserved)
//
// Conditional clusters:
//   - WINDOW   emitted when the monitor's perf logic is enabled
//   - ADDR_RNG emitted when N_ADDR_RANGES > 0 for that monitor

addrmap bridge_1x2_rd_regblock_mon_cfg {
    name = "bridge_1x2_rd_regblock_mon monitor cfg";
    desc = "AXIL-mapped cfg backing the bridge's monitor enables, masks, window control, and address-range checker.";

    default regwidth = 32;
    default accesswidth = 32;
    default sw = rw;
    default hw = r;

    // ----------------------------------------------------------------
    // cpu_rd_0 RD direction
    // ----------------------------------------------------------------
    reg {
        name = "cpu_rd_0 RD CTRL";
        desc = "Per-cone enables (bits [6:0]) and timeout_cycles (bits [31:16]).";
        field { reset = 1'h1; } monitor_enable[0:0];
        field { reset = 1'h1; } error_enable[1:1];
        field { reset = 1'h0; } timeout_enable[2:2];
        field { reset = 1'h0; } perf_enable[3:3];
        field { reset = 1'h0; } compl_enable[4:4];
        field { reset = 1'h0; } threshold_enable[5:5];
        field { reset = 1'h0; } debug_enable[6:6];
        field { reset = 16'h0400; } timeout_cycles[31:16];
    } CPU_RD_0_RD_CTRL;

    reg {
        name = "cpu_rd_0 RD LATENCY";
        field { reset = 32'h00000200; } latency_threshold[31:0];
    } CPU_RD_0_RD_LATENCY;

    reg {
        name = "cpu_rd_0 RD MASKS_A";
        field { reset = 16'h0000; } axi_pkt_mask[15:0];
        field { reset = 16'h0000; } axi_err_select[31:16];
    } CPU_RD_0_RD_MASKS_A;

    reg {
        name = "cpu_rd_0 RD MASKS_B";
        field { reset = 16'h0000; } axi_error_mask[15:0];
        field { reset = 16'h0000; } axi_timeout_mask[31:16];
    } CPU_RD_0_RD_MASKS_B;

    reg {
        name = "cpu_rd_0 RD MASKS_C";
        field { reset = 16'h0000; } axi_compl_mask[15:0];
        field { reset = 16'h0000; } axi_thresh_mask[31:16];
    } CPU_RD_0_RD_MASKS_C;

    reg {
        name = "cpu_rd_0 RD MASKS_D";
        field { reset = 16'h0000; } axi_perf_mask[15:0];
        field { reset = 16'h0000; } axi_addr_mask[31:16];
    } CPU_RD_0_RD_MASKS_D;

    reg {
        name = "cpu_rd_0 RD MASKS_E";
        field { reset = 16'h0000; } axi_debug_mask[15:0];
    } CPU_RD_0_RD_MASKS_E;

    // Window cfg — present because the monitor enables the perf cone.
    reg {
        name = "cpu_rd_0 RD WINDOW_CTRL";
        desc = "Stage A window-trigger config.";
        field { reset = 3'b111; } start_event_sel[2:0];   // never-fire
        field { reset = 3'b111; } end_event_sel[5:3];     // never-fire
        field { reset = 1'b0;   } start_trigger[6:6];
        field { reset = 1'b0;   } end_trigger[7:7];
        field { reset = 1'b0;   } window_force_close[8:8];
    } CPU_RD_0_RD_WINDOW_CTRL;

    // ----------------------------------------------------------------
    // ddr_rd_0 WR direction
    // ----------------------------------------------------------------
    reg {
        name = "ddr_rd_0 WR CTRL";
        desc = "Per-cone enables (bits [6:0]) and timeout_cycles (bits [31:16]).";
        field { reset = 1'h1; } monitor_enable[0:0];
        field { reset = 1'h1; } error_enable[1:1];
        field { reset = 1'h0; } timeout_enable[2:2];
        field { reset = 1'h0; } perf_enable[3:3];
        field { reset = 1'h0; } compl_enable[4:4];
        field { reset = 1'h0; } threshold_enable[5:5];
        field { reset = 1'h0; } debug_enable[6:6];
        field { reset = 16'h0400; } timeout_cycles[31:16];
    } DDR_RD_0_WR_CTRL;

    reg {
        name = "ddr_rd_0 WR LATENCY";
        field { reset = 32'h00000200; } latency_threshold[31:0];
    } DDR_RD_0_WR_LATENCY;

    reg {
        name = "ddr_rd_0 WR MASKS_A";
        field { reset = 16'h0000; } axi_pkt_mask[15:0];
        field { reset = 16'h0000; } axi_err_select[31:16];
    } DDR_RD_0_WR_MASKS_A;

    reg {
        name = "ddr_rd_0 WR MASKS_B";
        field { reset = 16'h0000; } axi_error_mask[15:0];
        field { reset = 16'h0000; } axi_timeout_mask[31:16];
    } DDR_RD_0_WR_MASKS_B;

    reg {
        name = "ddr_rd_0 WR MASKS_C";
        field { reset = 16'h0000; } axi_compl_mask[15:0];
        field { reset = 16'h0000; } axi_thresh_mask[31:16];
    } DDR_RD_0_WR_MASKS_C;

    reg {
        name = "ddr_rd_0 WR MASKS_D";
        field { reset = 16'h0000; } axi_perf_mask[15:0];
        field { reset = 16'h0000; } axi_addr_mask[31:16];
    } DDR_RD_0_WR_MASKS_D;

    reg {
        name = "ddr_rd_0 WR MASKS_E";
        field { reset = 16'h0000; } axi_debug_mask[15:0];
    } DDR_RD_0_WR_MASKS_E;

    // ----------------------------------------------------------------
    // ddr_rd_0 RD direction
    // ----------------------------------------------------------------
    reg {
        name = "ddr_rd_0 RD CTRL";
        desc = "Per-cone enables (bits [6:0]) and timeout_cycles (bits [31:16]).";
        field { reset = 1'h1; } monitor_enable[0:0];
        field { reset = 1'h1; } error_enable[1:1];
        field { reset = 1'h0; } timeout_enable[2:2];
        field { reset = 1'h0; } perf_enable[3:3];
        field { reset = 1'h0; } compl_enable[4:4];
        field { reset = 1'h0; } threshold_enable[5:5];
        field { reset = 1'h0; } debug_enable[6:6];
        field { reset = 16'h0400; } timeout_cycles[31:16];
    } DDR_RD_0_RD_CTRL;

    reg {
        name = "ddr_rd_0 RD LATENCY";
        field { reset = 32'h00000200; } latency_threshold[31:0];
    } DDR_RD_0_RD_LATENCY;

    reg {
        name = "ddr_rd_0 RD MASKS_A";
        field { reset = 16'h0000; } axi_pkt_mask[15:0];
        field { reset = 16'h0000; } axi_err_select[31:16];
    } DDR_RD_0_RD_MASKS_A;

    reg {
        name = "ddr_rd_0 RD MASKS_B";
        field { reset = 16'h0000; } axi_error_mask[15:0];
        field { reset = 16'h0000; } axi_timeout_mask[31:16];
    } DDR_RD_0_RD_MASKS_B;

    reg {
        name = "ddr_rd_0 RD MASKS_C";
        field { reset = 16'h0000; } axi_compl_mask[15:0];
        field { reset = 16'h0000; } axi_thresh_mask[31:16];
    } DDR_RD_0_RD_MASKS_C;

    reg {
        name = "ddr_rd_0 RD MASKS_D";
        field { reset = 16'h0000; } axi_perf_mask[15:0];
        field { reset = 16'h0000; } axi_addr_mask[31:16];
    } DDR_RD_0_RD_MASKS_D;

    reg {
        name = "ddr_rd_0 RD MASKS_E";
        field { reset = 16'h0000; } axi_debug_mask[15:0];
    } DDR_RD_0_RD_MASKS_E;

    // ----------------------------------------------------------------
    // sram_rd_1 WR direction
    // ----------------------------------------------------------------
    reg {
        name = "sram_rd_1 WR CTRL";
        desc = "Per-cone enables (bits [6:0]) and timeout_cycles (bits [31:16]).";
        field { reset = 1'h1; } monitor_enable[0:0];
        field { reset = 1'h1; } error_enable[1:1];
        field { reset = 1'h0; } timeout_enable[2:2];
        field { reset = 1'h0; } perf_enable[3:3];
        field { reset = 1'h0; } compl_enable[4:4];
        field { reset = 1'h0; } threshold_enable[5:5];
        field { reset = 1'h0; } debug_enable[6:6];
        field { reset = 16'h0400; } timeout_cycles[31:16];
    } SRAM_RD_1_WR_CTRL;

    reg {
        name = "sram_rd_1 WR LATENCY";
        field { reset = 32'h00000200; } latency_threshold[31:0];
    } SRAM_RD_1_WR_LATENCY;

    reg {
        name = "sram_rd_1 WR MASKS_A";
        field { reset = 16'h0000; } axi_pkt_mask[15:0];
        field { reset = 16'h0000; } axi_err_select[31:16];
    } SRAM_RD_1_WR_MASKS_A;

    reg {
        name = "sram_rd_1 WR MASKS_B";
        field { reset = 16'h0000; } axi_error_mask[15:0];
        field { reset = 16'h0000; } axi_timeout_mask[31:16];
    } SRAM_RD_1_WR_MASKS_B;

    reg {
        name = "sram_rd_1 WR MASKS_C";
        field { reset = 16'h0000; } axi_compl_mask[15:0];
        field { reset = 16'h0000; } axi_thresh_mask[31:16];
    } SRAM_RD_1_WR_MASKS_C;

    reg {
        name = "sram_rd_1 WR MASKS_D";
        field { reset = 16'h0000; } axi_perf_mask[15:0];
        field { reset = 16'h0000; } axi_addr_mask[31:16];
    } SRAM_RD_1_WR_MASKS_D;

    reg {
        name = "sram_rd_1 WR MASKS_E";
        field { reset = 16'h0000; } axi_debug_mask[15:0];
    } SRAM_RD_1_WR_MASKS_E;

    // ----------------------------------------------------------------
    // sram_rd_1 RD direction
    // ----------------------------------------------------------------
    reg {
        name = "sram_rd_1 RD CTRL";
        desc = "Per-cone enables (bits [6:0]) and timeout_cycles (bits [31:16]).";
        field { reset = 1'h1; } monitor_enable[0:0];
        field { reset = 1'h1; } error_enable[1:1];
        field { reset = 1'h0; } timeout_enable[2:2];
        field { reset = 1'h0; } perf_enable[3:3];
        field { reset = 1'h0; } compl_enable[4:4];
        field { reset = 1'h0; } threshold_enable[5:5];
        field { reset = 1'h0; } debug_enable[6:6];
        field { reset = 16'h0400; } timeout_cycles[31:16];
    } SRAM_RD_1_RD_CTRL;

    reg {
        name = "sram_rd_1 RD LATENCY";
        field { reset = 32'h00000200; } latency_threshold[31:0];
    } SRAM_RD_1_RD_LATENCY;

    reg {
        name = "sram_rd_1 RD MASKS_A";
        field { reset = 16'h0000; } axi_pkt_mask[15:0];
        field { reset = 16'h0000; } axi_err_select[31:16];
    } SRAM_RD_1_RD_MASKS_A;

    reg {
        name = "sram_rd_1 RD MASKS_B";
        field { reset = 16'h0000; } axi_error_mask[15:0];
        field { reset = 16'h0000; } axi_timeout_mask[31:16];
    } SRAM_RD_1_RD_MASKS_B;

    reg {
        name = "sram_rd_1 RD MASKS_C";
        field { reset = 16'h0000; } axi_compl_mask[15:0];
        field { reset = 16'h0000; } axi_thresh_mask[31:16];
    } SRAM_RD_1_RD_MASKS_C;

    reg {
        name = "sram_rd_1 RD MASKS_D";
        field { reset = 16'h0000; } axi_perf_mask[15:0];
        field { reset = 16'h0000; } axi_addr_mask[31:16];
    } SRAM_RD_1_RD_MASKS_D;

    reg {
        name = "sram_rd_1 RD MASKS_E";
        field { reset = 16'h0000; } axi_debug_mask[15:0];
    } SRAM_RD_1_RD_MASKS_E;

    // ----------------------------------------------------------------
    // Group cfg — shared across all monitors at the monbus_axil_group.
    // Emitted from the bridge generator's _MON_GROUP_CFG tuple: 32-bit
    // fields each get their own MON_GROUP_<NAME> register; 16-bit
    // mask fields are packed two per register as MON_GROUP_PACK_<N>.
    // ----------------------------------------------------------------
    reg {
        name = "MON_GROUP_BASE_ADDR";
        desc = "mon_group base_addr (32-bit)";
        field { reset = 32'h00000000; } base_addr[31:0];
    } MON_GROUP_BASE_ADDR;

    reg {
        name = "MON_GROUP_LIMIT_ADDR";
        desc = "mon_group limit_addr (32-bit)";
        field { reset = 32'h00000000; } limit_addr[31:0];
    } MON_GROUP_LIMIT_ADDR;

    reg {
        name = "MON_GROUP_PACK_0";
        desc = "mon_group pack #0: flush_watermark + axi_pkt_mask";
        field { reset = 16'h0000; } flush_watermark[15:0];
        field { reset = 16'h0000; } axi_pkt_mask[31:16];
    } MON_GROUP_PACK_0;

    reg {
        name = "MON_GROUP_PACK_1";
        desc = "mon_group pack #1: axi_err_select + axi_error_mask";
        field { reset = 16'h0000; } axi_err_select[15:0];
        field { reset = 16'h0000; } axi_error_mask[31:16];
    } MON_GROUP_PACK_1;

    reg {
        name = "MON_GROUP_PACK_2";
        desc = "mon_group pack #2: axi_timeout_mask + axi_compl_mask";
        field { reset = 16'h0000; } axi_timeout_mask[15:0];
        field { reset = 16'h0000; } axi_compl_mask[31:16];
    } MON_GROUP_PACK_2;

    reg {
        name = "MON_GROUP_PACK_3";
        desc = "mon_group pack #3: axi_thresh_mask + axi_perf_mask";
        field { reset = 16'h0000; } axi_thresh_mask[15:0];
        field { reset = 16'h0000; } axi_perf_mask[31:16];
    } MON_GROUP_PACK_3;

    reg {
        name = "MON_GROUP_PACK_4";
        desc = "mon_group pack #4: axi_addr_mask + axi_debug_mask";
        field { reset = 16'h0000; } axi_addr_mask[15:0];
        field { reset = 16'h0000; } axi_debug_mask[31:16];
    } MON_GROUP_PACK_4;

    reg {
        name = "MON_GROUP_PACK_5";
        desc = "mon_group pack #5: axis_pkt_mask + axis_err_select";
        field { reset = 16'h0000; } axis_pkt_mask[15:0];
        field { reset = 16'h0000; } axis_err_select[31:16];
    } MON_GROUP_PACK_5;

    reg {
        name = "MON_GROUP_PACK_6";
        desc = "mon_group pack #6: axis_error_mask + axis_timeout_mask";
        field { reset = 16'h0000; } axis_error_mask[15:0];
        field { reset = 16'h0000; } axis_timeout_mask[31:16];
    } MON_GROUP_PACK_6;

    reg {
        name = "MON_GROUP_PACK_7";
        desc = "mon_group pack #7: axis_compl_mask + axis_credit_mask";
        field { reset = 16'h0000; } axis_compl_mask[15:0];
        field { reset = 16'h0000; } axis_credit_mask[31:16];
    } MON_GROUP_PACK_7;

    reg {
        name = "MON_GROUP_PACK_8";
        desc = "mon_group pack #8: axis_channel_mask + axis_stream_mask";
        field { reset = 16'h0000; } axis_channel_mask[15:0];
        field { reset = 16'h0000; } axis_stream_mask[31:16];
    } MON_GROUP_PACK_8;

    reg {
        name = "MON_GROUP_PACK_9";
        desc = "mon_group pack #9: core_pkt_mask + core_err_select";
        field { reset = 16'h0000; } core_pkt_mask[15:0];
        field { reset = 16'h0000; } core_err_select[31:16];
    } MON_GROUP_PACK_9;

    reg {
        name = "MON_GROUP_PACK_10";
        desc = "mon_group pack #10: core_error_mask + core_timeout_mask";
        field { reset = 16'h0000; } core_error_mask[15:0];
        field { reset = 16'h0000; } core_timeout_mask[31:16];
    } MON_GROUP_PACK_10;

    reg {
        name = "MON_GROUP_PACK_11";
        desc = "mon_group pack #11: core_compl_mask + core_thresh_mask";
        field { reset = 16'h0000; } core_compl_mask[15:0];
        field { reset = 16'h0000; } core_thresh_mask[31:16];
    } MON_GROUP_PACK_11;

    reg {
        name = "MON_GROUP_PACK_12";
        desc = "mon_group pack #12: core_perf_mask + core_debug_mask";
        field { reset = 16'h0000; } core_perf_mask[15:0];
        field { reset = 16'h0000; } core_debug_mask[31:16];
    } MON_GROUP_PACK_12;

};