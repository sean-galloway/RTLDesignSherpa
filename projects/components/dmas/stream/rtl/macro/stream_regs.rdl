// SPDX-License-Identifier: MIT
// SPDX-FileCopyrightText: 2024-2025 sean galloway
//
// STREAM Register Definition - PeakRDL Format
// Enhanced with full monitor configuration fields
//
// Address Space Layout:
//   0x000 - 0x03F: Channel kick-off registers (handled by apb4todescr.sv)
//                  - 16 registers: CHx_CTRL_LOW + CHx_CTRL_HIGH for 8 channels
//                  - 64-bit descriptor addresses split across LOW/HIGH pairs
//   0x100 - 0x3FF: Control and status registers (this file)
//
// Notes:
//   - Channel kick-off registers (CHx_CTRL) are NOT defined here
//   - Those are routed directly to descriptor engines via apb4todescr.sv
//   - This file defines all other configuration and status registers
//   - Includes full monitor mask and threshold registers
//
// Author: sean galloway
// Created: 2025-11-21

`include "stream_mon_regs.rdl"

addrmap stream_regs {

    name = "STREAM DMA Engine Registers";
    desc = "Configuration and status registers for 8-channel STREAM DMA engine with full monitor control";

    default regwidth = 32;
    default accesswidth = 32;
    default alignment = 4;

    //=========================================================================
    // Channel kick-off registers (0x000 - 0x03F) -- WRITE-ONLY.
    // Writing the 64-bit descriptor address (LOW then HIGH) kicks the channel.
    // These are DEFINED HERE (not hand-stuffed into the regmap) so DV/host
    // resolve them by name and a regmap regen can never drop them. The actual
    // write is decoded by cmdrsp_router (0x000-0x03F -> apb4todescr), so there is
    // no PeakRDL storage/hwif effect (hw=na); they occupy the address map only.
    //=========================================================================
    reg { name="Ch0 kick LOW";  desc="Ch0 descriptor addr [31:0]  (write kicks)"; field { sw=w; hw=na; } DESC_ADDR_LOW[31:0]=0;  } CH0_CTRL_LOW  @ 0x000;
    reg { name="Ch0 kick HIGH"; desc="Ch0 descriptor addr [63:32] (write kicks)"; field { sw=w; hw=na; } DESC_ADDR_HIGH[31:0]=0; } CH0_CTRL_HIGH @ 0x004;
    reg { name="Ch1 kick LOW";  desc="Ch1 descriptor addr [31:0]  (write kicks)"; field { sw=w; hw=na; } DESC_ADDR_LOW[31:0]=0;  } CH1_CTRL_LOW  @ 0x008;
    reg { name="Ch1 kick HIGH"; desc="Ch1 descriptor addr [63:32] (write kicks)"; field { sw=w; hw=na; } DESC_ADDR_HIGH[31:0]=0; } CH1_CTRL_HIGH @ 0x00C;
    reg { name="Ch2 kick LOW";  desc="Ch2 descriptor addr [31:0]  (write kicks)"; field { sw=w; hw=na; } DESC_ADDR_LOW[31:0]=0;  } CH2_CTRL_LOW  @ 0x010;
    reg { name="Ch2 kick HIGH"; desc="Ch2 descriptor addr [63:32] (write kicks)"; field { sw=w; hw=na; } DESC_ADDR_HIGH[31:0]=0; } CH2_CTRL_HIGH @ 0x014;
    reg { name="Ch3 kick LOW";  desc="Ch3 descriptor addr [31:0]  (write kicks)"; field { sw=w; hw=na; } DESC_ADDR_LOW[31:0]=0;  } CH3_CTRL_LOW  @ 0x018;
    reg { name="Ch3 kick HIGH"; desc="Ch3 descriptor addr [63:32] (write kicks)"; field { sw=w; hw=na; } DESC_ADDR_HIGH[31:0]=0; } CH3_CTRL_HIGH @ 0x01C;
    reg { name="Ch4 kick LOW";  desc="Ch4 descriptor addr [31:0]  (write kicks)"; field { sw=w; hw=na; } DESC_ADDR_LOW[31:0]=0;  } CH4_CTRL_LOW  @ 0x020;
    reg { name="Ch4 kick HIGH"; desc="Ch4 descriptor addr [63:32] (write kicks)"; field { sw=w; hw=na; } DESC_ADDR_HIGH[31:0]=0; } CH4_CTRL_HIGH @ 0x024;
    reg { name="Ch5 kick LOW";  desc="Ch5 descriptor addr [31:0]  (write kicks)"; field { sw=w; hw=na; } DESC_ADDR_LOW[31:0]=0;  } CH5_CTRL_LOW  @ 0x028;
    reg { name="Ch5 kick HIGH"; desc="Ch5 descriptor addr [63:32] (write kicks)"; field { sw=w; hw=na; } DESC_ADDR_HIGH[31:0]=0; } CH5_CTRL_HIGH @ 0x02C;
    reg { name="Ch6 kick LOW";  desc="Ch6 descriptor addr [31:0]  (write kicks)"; field { sw=w; hw=na; } DESC_ADDR_LOW[31:0]=0;  } CH6_CTRL_LOW  @ 0x030;
    reg { name="Ch6 kick HIGH"; desc="Ch6 descriptor addr [63:32] (write kicks)"; field { sw=w; hw=na; } DESC_ADDR_HIGH[31:0]=0; } CH6_CTRL_HIGH @ 0x034;
    reg { name="Ch7 kick LOW";  desc="Ch7 descriptor addr [31:0]  (write kicks)"; field { sw=w; hw=na; } DESC_ADDR_LOW[31:0]=0;  } CH7_CTRL_LOW  @ 0x038;
    reg { name="Ch7 kick HIGH"; desc="Ch7 descriptor addr [63:32] (write kicks)"; field { sw=w; hw=na; } DESC_ADDR_HIGH[31:0]=0; } CH7_CTRL_HIGH @ 0x03C;

    //=========================================================================
    // Global Control and Status (0x100 - 0x11F)
    //=========================================================================

    reg {
        name = "Global Control Register";
        desc = "Master enable and global configuration";

        field {
            desc = "Global enable - master switch for entire STREAM engine";
            sw = rw;
            hw = r;
        } GLOBAL_EN = 1'b0;

        field {
            desc = "Global reset - resets all channels and state machines";
            sw = rw;
            hw = r;
            swmod;  // Self-clearing
        } GLOBAL_RST = 1'b0;

        field {
            desc = "Reserved";
            sw = r;
            hw = na;
        } RSVD[31:2] = 30'h0;

    } GLOBAL_CTRL @ 0x100;


    reg {
        name = "Global Status Register";
        desc = "Overall system status and error flags";

        field {
            desc = "System idle - all channels idle";
            sw = r;
            hw = w;
        } SYSTEM_IDLE;

        field {
            desc = "Reserved";
            sw = r;
            hw = na;
        } RSVD[31:1] = 31'h0;

    } GLOBAL_STATUS @ 0x104;


    reg {
        name = "Version Register";
        desc = "STREAM version and configuration information";

        field {
            desc = "Minor version";
            sw = r;
            hw = na;
        } MINOR[7:0] = 8'd90;  // 0.90

        field {
            desc = "Major version";
            sw = r;
            hw = na;
        } MAJOR[15:8] = 8'h00;  // 0.90 (pre-release)

        field {
            desc = "Number of channels";
            sw = r;
            hw = na;
        } NUM_CHANNELS[23:16] = 8'h08;

        field {
            desc = "Reserved";
            sw = r;
            hw = na;
        } RSVD[31:24] = 8'h0;

    } VERSION @ 0x108;


    //=========================================================================
    // Per-Channel Control (0x120 - 0x13F)
    //=========================================================================

    reg {
        name = "Channel Enable Register";
        desc = "Per-channel enable bits (one bit per channel)";

        field {
            desc = "Channel enable bits [7:0] - 1=enabled, 0=disabled";
            sw = rw;
            hw = r;
        } CH_EN[7:0] = 8'h00;

        field {
            desc = "Reserved";
            sw = r;
            hw = na;
        } RSVD[31:8] = 24'h0;

    } CHANNEL_ENABLE @ 0x120;


    reg {
        name = "Channel Reset Register";
        desc = "Per-channel reset bits (one bit per channel, self-clearing)";

        field {
            desc = "Channel reset bits [7:0] - write 1 to reset channel";
            sw = rw;
            hw = r;
            swmod;  // Self-clearing
        } CH_RST[7:0] = 8'h00;

        field {
            desc = "Reserved";
            sw = r;
            hw = na;
        } RSVD[31:8] = 24'h0;

    } CHANNEL_RESET @ 0x124;


    //=========================================================================
    // Per-Channel Status (0x140 - 0x17F)
    //=========================================================================

    reg {
        name = "Channel Idle Status";
        desc = "Per-channel idle status (one bit per channel)";

        field {
            desc = "Channel idle bits [7:0] - 1=idle, 0=active";
            sw = r;
            hw = w;
        } CH_IDLE[7:0];

        field {
            desc = "Reserved";
            sw = r;
            hw = na;
        } RSVD[31:8] = 24'h0;

    } CHANNEL_IDLE @ 0x140;


    reg {
        name = "Descriptor Engine Idle Status";
        desc = "Per-channel descriptor engine idle status";

        field {
            desc = "Descriptor engine idle bits [7:0] - 1=idle, 0=active";
            sw = r;
            hw = w;
        } DESC_IDLE[7:0];

        field {
            desc = "Reserved";
            sw = r;
            hw = na;
        } RSVD[31:8] = 24'h0;

    } DESC_ENGINE_IDLE @ 0x144;


    reg {
        name = "Scheduler Idle Status";
        desc = "Per-channel scheduler idle status";

        field {
            desc = "Scheduler idle bits [7:0] - 1=idle, 0=active";
            sw = r;
            hw = w;
        } SCHED_IDLE[7:0];

        field {
            desc = "Reserved";
            sw = r;
            hw = na;
        } RSVD[31:8] = 24'h0;

    } SCHEDULER_IDLE @ 0x148;


    // Per-channel state registers (CH0-CH7)
    regfile {
        name = "Per-Channel State Registers";
        desc = "Detailed state for individual channel";

        reg {
            name = "Channel State";
            desc = "Current FSM state of scheduler (one-hot 7-bit encoding)";

            field {
                desc = "Scheduler state [6:0] - one-hot encoding";
                sw = r;
                hw = w;
            } STATE[6:0];

            field {
                desc = "Reserved";
                sw = r;
                hw = na;
            } RSVD[31:7] = 25'h0;

        } STATE @ 0x0;

    } CH_STATE[8] @ 0x150 += 0x4;


    //=========================================================================
    // Engine Completion and Error Status (0x170 - 0x17F)
    //=========================================================================

    reg {
        name = "Scheduler Error Status";
        desc = "Per-channel scheduler error flags";

        field {
            desc = "Scheduler error bits [7:0] - 1=error detected, 0=no error";
            sw = r;
            hw = w;
        } SCHED_ERR[7:0];

        field {
            desc = "Reserved";
            sw = r;
            hw = na;
        } RSVD[31:8] = 24'h0;

    } SCHED_ERROR @ 0x170;


    reg {
        name = "AXI Read Engine Completion Status";
        desc = "Per-channel read engine all_complete flags";

        field {
            desc = "Read completion bits [7:0] - 1=all reads complete, 0=reads pending";
            sw = r;
            hw = w;
        } RD_COMPLETE[7:0];

        field {
            desc = "Reserved";
            sw = r;
            hw = na;
        } RSVD[31:8] = 24'h0;

    } AXI_RD_COMPLETE @ 0x174;


    reg {
        name = "AXI Write Engine Completion Status";
        desc = "Per-channel write engine all_complete flags";

        field {
            desc = "Write completion bits [7:0] - 1=all writes complete, 0=writes pending";
            sw = r;
            hw = w;
        } WR_COMPLETE[7:0];

        field {
            desc = "Reserved";
            sw = r;
            hw = na;
        } RSVD[31:8] = 24'h0;

    } AXI_WR_COMPLETE @ 0x178;


    //=========================================================================
    // Scheduler Configuration (0x200 - 0x21F)
    //=========================================================================

    reg {
        name = "Scheduler Timeout Cycles";
        desc = "Timeout threshold in clock cycles (global for all channels)";

        field {
            desc = "Timeout cycles [31:0] - number of cycles before timeout";
            sw = rw;
            hw = r;
        } TIMEOUT_CYCLES[31:0] = 32'd1000;

    } SCHED_TIMEOUT_CYCLES @ 0x200;


    reg {
        name = "Scheduler Configuration";
        desc = "Scheduler feature enables (global for all channels)";

        field {
            desc = "Scheduler enable - master scheduler enable";
            sw = rw;
            hw = r;
        } SCHED_EN = 1'b1;

        field {
            desc = "Timeout enable - enable timeout detection";
            sw = rw;
            hw = r;
        } TIMEOUT_EN = 1'b1;

        field {
            desc = "Error enable - enable error reporting";
            sw = rw;
            hw = r;
        } ERR_EN = 1'b1;

        field {
            desc = "Completion enable - enable completion reporting";
            sw = rw;
            hw = r;
        } COMPL_EN = 1'b1;

        field {
            desc = "Performance enable - enable performance monitoring";
            sw = rw;
            hw = r;
        } PERF_EN = 1'b0;

        field {
            desc = "Read-ahead descriptor prefetch enable. When set, on a chained
                    legacy descriptor the scheduler read side loads the next
                    descriptor from the descriptor-FIFO head and keeps filling SRAM
                    while the write side drains the current one -- collapsing the
                    per-descriptor boundary bubble to zero (perfect cross-descriptor
                    streaming). Default enabled; clear for lockstep A/B on the same
                    bitstream. Ignored for EXT (row/col) descriptors.";
            sw = rw;
            hw = r;
        } RD_PREFETCH_EN = 1'b1;

        field {
            desc = "Reserved";
            sw = r;
            hw = na;
        } RSVD[31:6] = 26'h0;

    } SCHED_CONFIG @ 0x204;


    reg {
        name = "Scheduler Timeout Escalation Limit";
        desc = "Number of consecutive write-progress timeout windows a channel may
                tolerate before the (recoverable) timeout escalates to a fatal,
                sticky CH_ERROR. 0 = never escalate (pure soft timeout: report and
                keep waiting). Total time to escalate = LIMIT x TIMEOUT_CYCLES.";

        field {
            desc = "Consecutive-timeout strike limit before fatal escalation (0 = never)";
            sw = rw;
            hw = r;
        } LIMIT[7:0] = 8'd4;

    } SCHED_TIMEOUT_LIMIT @ 0x208;


    //=========================================================================
    // Descriptor Engine Configuration (0x220 - 0x23F)
    //=========================================================================

    reg {
        name = "Descriptor Engine Configuration";
        desc = "Descriptor engine feature enables (global for all channels)";

        field {
            desc = "Descriptor engine enable - master enable";
            sw = rw;
            hw = r;
        } DESCENG_EN = 1'b1;

        field {
            desc = "Prefetch enable - enable descriptor prefetch. Default ENABLED:
                    with prefetch off the descriptor engine is on-demand (fetch the
                    next descriptor only after the current one drains), which inserts
                    a per-descriptor pipeline drain/refill bubble (~40 cycles) on
                    chains. Prefetch buffers FIFO_THRESH descriptors ahead so the
                    datapath streams continuously across descriptor boundaries.";
            sw = rw;
            hw = r;
        } PREFETCH_EN = 1'b1;

        field {
            desc = "FIFO threshold [5:2] - prefetch threshold (4 bits)";
            sw = rw;
            hw = r;
        } FIFO_THRESH[5:2] = 4'h8;

        field {
            desc = "Reserved";
            sw = r;
            hw = na;
        } RSVD[31:6] = 26'h0;

    } DESCENG_CONFIG @ 0x220;


    reg {
        name = "Descriptor Address Range 0 Base";
        desc = "Base address for descriptor address range 0 (lower 32 bits)";

        field {
            desc = "Address range 0 base [31:0]";
            sw = rw;
            hw = r;
        } ADDR0_BASE[31:0] = 32'h0000_0000;

    } DESCENG_ADDR0_BASE @ 0x224;


    reg {
        name = "Descriptor Address Range 0 Limit";
        desc = "Limit address for descriptor address range 0 (lower 32 bits)";

        field {
            desc = "Address range 0 limit [31:0]";
            sw = rw;
            hw = r;
        } ADDR0_LIMIT[31:0] = 32'hFFFF_FFFF;

    } DESCENG_ADDR0_LIMIT @ 0x228;


    reg {
        name = "Descriptor Address Range 1 Base";
        desc = "Base address for descriptor address range 1 (lower 32 bits)";

        field {
            desc = "Address range 1 base [31:0]";
            sw = rw;
            hw = r;
        } ADDR1_BASE[31:0] = 32'h0000_0000;

    } DESCENG_ADDR1_BASE @ 0x22C;


    reg {
        name = "Descriptor Address Range 1 Limit";
        desc = "Limit address for descriptor address range 1 (lower 32 bits)";

        field {
            desc = "Address range 1 limit [31:0]";
            sw = rw;
            hw = r;
        } ADDR1_LIMIT[31:0] = 32'hFFFF_FFFF;

    } DESCENG_ADDR1_LIMIT @ 0x230;


    //=========================================================================
    // AXI Transfer Configuration (0x2A0 - 0x2AF)
    //=========================================================================

    reg {
        name = "AXI Transfer Configuration";
        desc = "AXI read and write transfer burst sizes";

        field {
            desc = "AXI read transfer beats [7:0] - ARLEN value (0-255 represents 1-256 beats)";
            sw = rw;
            hw = r;
        } RD_XFER_BEATS[7:0] = 8'd15;

        field {
            desc = "AXI write transfer beats [15:8] - AWLEN value (0-255 represents 1-256 beats)";
            sw = rw;
            hw = r;
        } WR_XFER_BEATS[15:8] = 8'd15;

        field {
            desc = "Reserved";
            sw = r;
            hw = na;
        } RSVD[31:16] = 16'h0;

    } AXI_XFER_CONFIG @ 0x2A0;


    //=========================================================================
    // Performance Profiler Configuration (0x2B0 - 0x2BF)
    //=========================================================================

    reg {
        name = "Performance Profiler Configuration";
        desc = "Performance profiler enable and mode controls";

        field {
            desc = "Performance profiler enable";
            sw = rw;
            hw = r;
        } PERF_EN = 1'b0;

        field {
            desc = "Performance profiler mode - 0=count, 1=histogram";
            sw = rw;
            hw = r;
        } PERF_MODE = 1'b0;

        field {
            desc = "Performance profiler clear - write 1 to clear counters";
            sw = rw;
            hw = r;
            swmod;  // Self-clearing
        } PERF_CLEAR = 1'b0;

        field {
            desc = "Reserved";
            sw = r;
            hw = na;
        } RSVD[31:3] = 29'h0;

    } PERF_CONFIG @ 0x2B0;


    //=========================================================================
    // Channel-Observation Mux (0x2C0 - 0x2CF)
    //=========================================================================
    // Lets software probe one (channel, category) lane of internal STREAM
    // state at a time without touching the AXI monitor bus. The mux lives in
    // stream_core; OBS_CTRL selects what stream_config_block forwards into
    // the OBS_FLAGS / OBS_DATA0 / OBS_DATA1 read-back registers below.

    reg {
        name = "Observation Mux Control";
        desc = "Selects which channel and which category drive OBS_FLAGS / OBS_DATA0 / OBS_DATA1";

        field {
            desc = "Channel select (0..NUM_CHANNELS-1)";
            sw = rw;
            hw = r;
        } CH_SEL[2:0] = 3'b0;

        field {
            desc = "Category select: 0=status (data0=sched_rd_beats, data1=sched_wr_beats), 1=rd_addr (data0=lo, data1=hi), 2=wr_addr (data0=lo, data1=hi), 3=sram (data0=rd_space_free, data1=wr_data_avail)";
            sw = rw;
            hw = r;
        } CAT_SEL[4:3] = 2'b0;

        field {
            desc = "Reserved";
            sw = r;
            hw = na;
        } RSVD[31:5] = 27'h0;

    } OBS_CTRL @ 0x2C0;


    reg {
        name = "Observation Flags";
        desc = "Combinational status vector for the channel selected by OBS_CTRL.CH_SEL. See stream_core.sv for the bit layout (scheduler_state, sched_rd/wr_valid, sched_wr_ready, error stickies, idle bits, cfg_channel_enable, axi_*_all_complete).";

        field {
            desc = "Observation flags";
            sw = r;
            hw = w;
        } FLAGS[31:0];

    } OBS_FLAGS @ 0x2C4;


    reg {
        name = "Observation Data 0";
        desc = "Category-muxed data word 0 for the selected channel. Semantics depend on OBS_CTRL.CAT_SEL.";

        field {
            desc = "Observation data 0";
            sw = r;
            hw = w;
        } DATA[31:0];

    } OBS_DATA0 @ 0x2C8;


    reg {
        name = "Observation Data 1";
        desc = "Category-muxed data word 1 for the selected channel. Semantics depend on OBS_CTRL.CAT_SEL.";

        field {
            desc = "Observation data 1";
            sw = r;
            hw = w;
        } DATA[31:0];

    } OBS_DATA1 @ 0x2CC;


    //=========================================================================
    // Per-Channel Datapath Perf Buckets (RFC Stage C, indexed readout)
    //=========================================================================
    // RFC-perfmon Stage C via the in-core axi_bus_meter blocks. Rather than
    // NUM_CHANNELS x 4 buckets x 2 buses flat registers, software selects a
    // channel with PERF_CH_SEL.CH_SEL and reads that channel's four 16-bit
    // buckets through the packed RD/WRMON_PERF_CH_* registers below (same
    // {bp,prod} / {idle,starv} packing as the FPGA-char harness meter, so the
    // host decode is identical). Per-channel counters are 16-bit and share the
    // RD/WRMON_PERF_CTRL.RUN window with the aggregate buckets; the per-channel
    // OVERFLOW stickies flag any 16-bit wrap. Summed over channels the buckets
    // equal the aggregate RD/WRMON_PERF buckets.

    reg {
        name = "Per-Channel Perf Bucket Readout Select";
        desc = "Selects which channel's buckets appear in RD/WRMON_PERF_CH_*";

        field {
            desc = "Channel select (0..NUM_CHANNELS-1)";
            sw = rw;
            hw = r;
        } CH_SEL[2:0] = 3'h0;

        field {
            desc = "Reserved";
            sw = r;
            hw = na;
        } RSVD[31:3] = 29'h0;

    } PERF_CH_SEL @ 0x35C;


    //=========================================================================
    // Datapath Latency Histograms (RFC Stage D, indexed readout)
    //=========================================================================
    // Per-transaction latency distribution for the data-read and data-write
    // buses, binned into 16 log2 bins (bin b counts transactions whose latency
    // is in [2^b, 2^(b+1)) cycles; bin 15 is the saturating tail). This is the
    // only genuinely-new perfmon data versus the legacy axi_bus_meter. To avoid
    // 3 metrics x 16 bins x 2 buses flat registers it uses indexed readout:
    // write HIST_SEL (bus, metric, bin), then read HIST_DATA (that bin's count)
    // and HIST_TOTAL (the selected bus+metric's total transaction count, which
    // equals the sum over bins). Latencies are measured over the same RUN window
    // as RD/WRMON_PERF_CTRL (the histogram shares the perf-window clear/freeze).
    //
    // Metrics:
    //   bus=0 (read):  metric 0 = AR handshake -> first R beat
    //                  metric 1 = AR handshake -> RLAST beat
    //   bus=1 (write): metric 0 = AW handshake -> B response (metric 1 unused)

    reg {
        name = "Latency Histogram Readout Select";
        desc = "Selects bus/metric/bin presented in HIST_DATA / HIST_TOTAL";

        field {
            desc = "Bus: 0=data-read R bus, 1=data-write W bus";
            sw = rw;
            hw = r;
        } BUS = 1'b0;

        field {
            desc = "Metric: 0=AR->firstR (rd) / AW->B (wr), 1=AR->RLAST (rd only)";
            sw = rw;
            hw = r;
        } METRIC = 1'b0;

        field {
            desc = "Latency bin index (0..15, log2)";
            sw = rw;
            hw = r;
        } BIN[5:2] = 4'h0;

        field {
            desc = "Reserved";
            sw = r;
            hw = na;
        } RSVD[31:6] = 26'h0;

    } HIST_SEL @ 0x378;


    reg {
        name = "Latency Histogram Bin Count";
        desc = "Transaction count in the HIST_SEL-selected bus/metric/bin";

        field {
            desc = "Selected histogram bin count [31:0]";
            sw = r;
            hw = w;
        } VAL[31:0];

    } HIST_DATA @ 0x37C;


    reg {
        name = "Latency Histogram Metric Total";
        desc = "Total transactions for the HIST_SEL-selected bus/metric (= sum
                over all bins). Equals the burst/transaction count, an
                acceptance cross-check against the perf-window burst counters.";

        field {
            desc = "Selected metric total transaction count [31:0]";
            sw = r;
            hw = w;
        } VAL[31:0];

    } HIST_TOTAL @ 0x380;

    //=========================================================================
    // AXI Monitor register block (relocatable) - same APB slave, base 0x1000.
    // Hookup chosen by a parameter at integration (USE_AXI_MONITORS).
    //=========================================================================
    stream_mon_regs MON @ 0x1000;

};
