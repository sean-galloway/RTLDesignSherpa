// SPDX-License-Identifier: MIT
// SPDX-FileCopyrightText: 2024-2025 sean galloway
//
// RAPIDS (beats) per-engine register file (source OR sink engine): all
// config/status registers + an optional monitor block (MON @ +0x800).
// Instantiated twice by rapids_regs.rdl (SRC @ 0x0000, SNK @ 0x1000), and once
// by rapids_regmap.rdl for per-instance by-name DV access (RegisterMap used with
// base 0x0000 / 0x1000).
//
// Author: sean galloway

`include "rapids_mon_regs.rdl"

// One RAPIDS engine instance (source or sink): all config/status registers + an
// optional monitor register block. Instantiated twice by the rapids_regs addrmap
// below (SRC @ 0x0000, SNK @ 0x1000) so each instance is a self-contained 4KB
// register space off the single shared APB port. Monitors live at +0x800 within
// the instance.
regfile rapids_engine_regs {
    name = "RAPIDS (beats) per-engine register file";
    desc = "Config/status + monitors for one RAPIDS engine (source or sink)";

    default regwidth = 32;
    default accesswidth = 32;
    default alignment = 4;

    //=========================================================================
    // Channel descriptor staging (0x000-0x03F) and launch (0x040)
    //=========================================================================
    // Software stages a 64-bit descriptor address per channel in
    // CHx_DESC_ADDR_{LOW,HIGH} and then launches with ONE write to
    // KICK_ENABLE. The address registers STORE (sw=rw, hw=r); writing one no
    // longer kicks by itself.
    //
    // This replaces the old kick block, which snooped the raw APB command stream so
    // that the ADDRESS WRITE ITSELF kicked. Two consequences it had: the
    // staged address was never readable state, and an N-channel launch cost N
    // APB transactions, so channel 0 was already running before the last
    // channel started -- long enough to bias any cross-channel measurement.
    // One 32-bit write to KICK_ENABLE now starts every channel on the same
    // cycle.
    //
    // The addresses deliberately keep the old kick window geometry (channel*8,
    // +0 = LOW, +4 = HIGH), so an existing writer stages the same words at the
    // same offsets; only the separate launch write is new.

    reg { name="Ch0 desc addr LOW";  desc="Ch0 descriptor address [31:0] (staged; launch via KICK_ENABLE)"; field { sw=rw; hw=r; } DESC_ADDR_LOW[31:0]=0;  } CH0_DESC_ADDR_LOW  @ 0x000;
    reg { name="Ch0 desc addr HIGH"; desc="Ch0 descriptor address [63:32] (staged; launch via KICK_ENABLE)"; field { sw=rw; hw=r; } DESC_ADDR_HIGH[31:0]=0; } CH0_DESC_ADDR_HIGH @ 0x004;
    reg { name="Ch1 desc addr LOW";  desc="Ch1 descriptor address [31:0] (staged; launch via KICK_ENABLE)"; field { sw=rw; hw=r; } DESC_ADDR_LOW[31:0]=0;  } CH1_DESC_ADDR_LOW  @ 0x008;
    reg { name="Ch1 desc addr HIGH"; desc="Ch1 descriptor address [63:32] (staged; launch via KICK_ENABLE)"; field { sw=rw; hw=r; } DESC_ADDR_HIGH[31:0]=0; } CH1_DESC_ADDR_HIGH @ 0x00C;
    reg { name="Ch2 desc addr LOW";  desc="Ch2 descriptor address [31:0] (staged; launch via KICK_ENABLE)"; field { sw=rw; hw=r; } DESC_ADDR_LOW[31:0]=0;  } CH2_DESC_ADDR_LOW  @ 0x010;
    reg { name="Ch2 desc addr HIGH"; desc="Ch2 descriptor address [63:32] (staged; launch via KICK_ENABLE)"; field { sw=rw; hw=r; } DESC_ADDR_HIGH[31:0]=0; } CH2_DESC_ADDR_HIGH @ 0x014;
    reg { name="Ch3 desc addr LOW";  desc="Ch3 descriptor address [31:0] (staged; launch via KICK_ENABLE)"; field { sw=rw; hw=r; } DESC_ADDR_LOW[31:0]=0;  } CH3_DESC_ADDR_LOW  @ 0x018;
    reg { name="Ch3 desc addr HIGH"; desc="Ch3 descriptor address [63:32] (staged; launch via KICK_ENABLE)"; field { sw=rw; hw=r; } DESC_ADDR_HIGH[31:0]=0; } CH3_DESC_ADDR_HIGH @ 0x01C;
    reg { name="Ch4 desc addr LOW";  desc="Ch4 descriptor address [31:0] (staged; launch via KICK_ENABLE)"; field { sw=rw; hw=r; } DESC_ADDR_LOW[31:0]=0;  } CH4_DESC_ADDR_LOW  @ 0x020;
    reg { name="Ch4 desc addr HIGH"; desc="Ch4 descriptor address [63:32] (staged; launch via KICK_ENABLE)"; field { sw=rw; hw=r; } DESC_ADDR_HIGH[31:0]=0; } CH4_DESC_ADDR_HIGH @ 0x024;
    reg { name="Ch5 desc addr LOW";  desc="Ch5 descriptor address [31:0] (staged; launch via KICK_ENABLE)"; field { sw=rw; hw=r; } DESC_ADDR_LOW[31:0]=0;  } CH5_DESC_ADDR_LOW  @ 0x028;
    reg { name="Ch5 desc addr HIGH"; desc="Ch5 descriptor address [63:32] (staged; launch via KICK_ENABLE)"; field { sw=rw; hw=r; } DESC_ADDR_HIGH[31:0]=0; } CH5_DESC_ADDR_HIGH @ 0x02C;
    reg { name="Ch6 desc addr LOW";  desc="Ch6 descriptor address [31:0] (staged; launch via KICK_ENABLE)"; field { sw=rw; hw=r; } DESC_ADDR_LOW[31:0]=0;  } CH6_DESC_ADDR_LOW  @ 0x030;
    reg { name="Ch6 desc addr HIGH"; desc="Ch6 descriptor address [63:32] (staged; launch via KICK_ENABLE)"; field { sw=rw; hw=r; } DESC_ADDR_HIGH[31:0]=0; } CH6_DESC_ADDR_HIGH @ 0x034;
    reg { name="Ch7 desc addr LOW";  desc="Ch7 descriptor address [31:0] (staged; launch via KICK_ENABLE)"; field { sw=rw; hw=r; } DESC_ADDR_LOW[31:0]=0;  } CH7_DESC_ADDR_LOW  @ 0x038;
    reg { name="Ch7 desc addr HIGH"; desc="Ch7 descriptor address [63:32] (staged; launch via KICK_ENABLE)"; field { sw=rw; hw=r; } DESC_ADDR_HIGH[31:0]=0; } CH7_DESC_ADDR_HIGH @ 0x03C;

    reg {
        name = "Kick enable";
        desc = "Write 1 to bit[ch] to launch that channel from its staged CHx_DESC_ADDR pair";

        // One singlepulse field per channel rather than a single 8-bit field:
        // SystemRDL requires singlepulse to be width 1. They share a register,
        // so a single 32-bit write still launches every channel on the same
        // cycle -- the atomicity comes from the bus transaction, not the field
        // width. Each bit self-clears, so software never clears it and a
        // re-read cannot be mistaken for a pending launch.
        field { sw=w; hw=r; singlepulse; } KICK0[0:0]=0;
        field { sw=w; hw=r; singlepulse; } KICK1[1:1]=0;
        field { sw=w; hw=r; singlepulse; } KICK2[2:2]=0;
        field { sw=w; hw=r; singlepulse; } KICK3[3:3]=0;
        field { sw=w; hw=r; singlepulse; } KICK4[4:4]=0;
        field { sw=w; hw=r; singlepulse; } KICK5[5:5]=0;
        field { sw=w; hw=r; singlepulse; } KICK6[6:6]=0;
        field { sw=w; hw=r; singlepulse; } KICK7[7:7]=0;

        field {
            desc = "Reserved";
            sw = r;
            hw = na;
        } RSVD[31:8] = 24'h0;

    } KICK_ENABLE @ 0x040;


    reg {
        name = "Global Control Register";
        desc = "Master enable and global configuration";

        field {
            desc = "Global enable - master switch for entire STREAM engine";
            sw = rw;
            hw = r;
        } GLOBAL_EN = 1'b0;

        field {
            desc = "Global reset - resets all channels and state machines";
            sw = rw;
            hw = r;
            swmod;  // Self-clearing
        } GLOBAL_RST = 1'b0;

        field {
            desc = "Reserved";
            sw = r;
            hw = na;
        } RSVD[31:2] = 30'h0;

    } GLOBAL_CTRL @ 0x100;

    reg {
        name = "Global Status Register";
        desc = "Overall system status and error flags";

        field {
            desc = "System idle - all channels idle";
            sw = r;
            hw = w;
        } SYSTEM_IDLE;

        field {
            desc = "Reserved";
            sw = r;
            hw = na;
        } RSVD[31:1] = 31'h0;

    } GLOBAL_STATUS @ 0x104;

    reg {
        name = "Version Register";
        desc = "STREAM version and configuration information";

        field {
            desc = "Minor version";
            sw = r;
            hw = na;
        } MINOR[7:0] = 8'd90;  // 0.90

        field {
            desc = "Major version";
            sw = r;
            hw = na;
        } MAJOR[15:8] = 8'h00;  // 0.90 (pre-release)

        field {
            desc = "Number of channels";
            sw = r;
            hw = na;
        } NUM_CHANNELS[23:16] = 8'h08;

        field {
            desc = "Reserved";
            sw = r;
            hw = na;
        } RSVD[31:24] = 8'h0;

    } VERSION @ 0x108;

    reg {
        name = "Channel Enable Register";
        desc = "Per-channel enable bits (one bit per channel)";

        field {
            desc = "Channel enable bits [7:0] - 1=enabled, 0=disabled";
            sw = rw;
            hw = r;
        } CH_EN[7:0] = 8'h00;

        field {
            desc = "Reserved";
            sw = r;
            hw = na;
        } RSVD[31:8] = 24'h0;

    } CHANNEL_ENABLE @ 0x120;

    reg {
        name = "Channel Reset Register";
        desc = "Per-channel reset bits (one bit per channel, self-clearing)";

        field {
            desc = "Channel reset bits [7:0] - write 1 to reset channel";
            sw = rw;
            hw = r;
            swmod;  // Self-clearing
        } CH_RST[7:0] = 8'h00;

        field {
            desc = "Reserved";
            sw = r;
            hw = na;
        } RSVD[31:8] = 24'h0;

    } CHANNEL_RESET @ 0x124;

    reg {
        name = "Channel Idle Status";
        desc = "Per-channel idle status (one bit per channel)";

        field {
            desc = "Channel idle bits [7:0] - 1=idle, 0=active";
            sw = r;
            hw = w;
        } CH_IDLE[7:0];

        field {
            desc = "Reserved";
            sw = r;
            hw = na;
        } RSVD[31:8] = 24'h0;

    } CHANNEL_IDLE @ 0x140;

    reg {
        name = "Descriptor Engine Idle Status";
        desc = "Per-channel descriptor engine idle status";

        field {
            desc = "Descriptor engine idle bits [7:0] - 1=idle, 0=active";
            sw = r;
            hw = w;
        } DESC_IDLE[7:0];

        field {
            desc = "Reserved";
            sw = r;
            hw = na;
        } RSVD[31:8] = 24'h0;

    } DESC_ENGINE_IDLE @ 0x144;

    reg {
        name = "Scheduler Idle Status";
        desc = "Per-channel scheduler idle status";

        field {
            desc = "Scheduler idle bits [7:0] - 1=idle, 0=active";
            sw = r;
            hw = w;
        } SCHED_IDLE[7:0];

        field {
            desc = "Reserved";
            sw = r;
            hw = na;
        } RSVD[31:8] = 24'h0;

    } SCHEDULER_IDLE @ 0x148;

    regfile {
        name = "Per-Channel State Registers";
        desc = "Detailed state for individual channel";

        reg {
            name = "Channel State";
            desc = "Current FSM state of scheduler (one-hot 7-bit encoding)";

            field {
                desc = "Scheduler state [6:0] - one-hot encoding";
                sw = r;
                hw = w;
            } STATE[6:0];

            field {
                desc = "Reserved";
                sw = r;
                hw = na;
            } RSVD[31:7] = 25'h0;

        } STATE @ 0x0;

    } CH_STATE[8] @ 0x150 += 0x4;

    reg {
        name = "Scheduler Error Status";
        desc = "Per-channel scheduler error flags";

        field {
            desc = "Scheduler error bits [7:0] - 1=error detected, 0=no error";
            sw = r;
            hw = w;
        } SCHED_ERR[7:0];

        field {
            desc = "Reserved";
            sw = r;
            hw = na;
        } RSVD[31:8] = 24'h0;

    } SCHED_ERROR @ 0x170;

    reg {
        name = "AXI Read Engine Completion Status";
        desc = "Per-channel read engine all_complete flags";

        field {
            desc = "Read completion bits [7:0] - 1=all reads complete, 0=reads pending";
            sw = r;
            hw = w;
        } RD_COMPLETE[7:0];

        field {
            desc = "Reserved";
            sw = r;
            hw = na;
        } RSVD[31:8] = 24'h0;

    } AXI_RD_COMPLETE @ 0x174;

    reg {
        name = "AXI Write Engine Completion Status";
        desc = "Per-channel write engine all_complete flags";

        field {
            desc = "Write completion bits [7:0] - 1=all writes complete, 0=writes pending";
            sw = r;
            hw = w;
        } WR_COMPLETE[7:0];

        field {
            desc = "Reserved";
            sw = r;
            hw = na;
        } RSVD[31:8] = 24'h0;

    } AXI_WR_COMPLETE @ 0x178;

    reg {
        name = "Scheduler Timeout Cycles";
        desc = "Timeout threshold in clock cycles (global for all channels)";

        field {
            desc = "Timeout cycles [31:0] - number of cycles before timeout";
            sw = rw;
            hw = r;
        } TIMEOUT_CYCLES[31:0] = 32'd1000;

    } SCHED_TIMEOUT_CYCLES @ 0x200;

    reg {
        name = "Scheduler Configuration";
        desc = "Scheduler feature enables (global for all channels)";

        field {
            desc = "Scheduler enable - master scheduler enable";
            sw = rw;
            hw = r;
        } SCHED_EN = 1'b1;

        field {
            desc = "Timeout enable - enable timeout detection";
            sw = rw;
            hw = r;
        } TIMEOUT_EN = 1'b1;

        field {
            desc = "Error enable - enable error reporting";
            sw = rw;
            hw = r;
        } ERR_EN = 1'b1;

        field {
            desc = "Completion enable. 1 = the scheduler and the descriptor engine report CORE Completion packets (descriptor loaded, descriptor/chain complete) on the monitor bus; 0 = those packets are dropped at the scheduler group, and the emitters are acknowledged so nothing stalls. Error packets are not gated by this bit (or by ERR_EN).";
            sw = rw;
            hw = r;
        } COMPL_EN = 1'b1;

        field {
            desc = "Performance enable - enable performance monitoring";
            sw = rw;
            hw = r;
        } PERF_EN = 1'b0;

        field {
            desc = "Reserved";
            sw = r;
            hw = na;
        } RSVD[31:5] = 27'h0;

    } SCHED_CONFIG @ 0x204;

    reg {
        name = "Scheduler Timeout Escalation Limit";
        desc = "Number of consecutive write-progress timeout windows a channel may
                tolerate before the (recoverable) timeout escalates to a fatal,
                sticky CH_ERROR. 0 = never escalate (pure soft timeout: report and
                keep waiting). Total time to escalate = LIMIT x TIMEOUT_CYCLES.";

        field {
            desc = "Consecutive-timeout strike limit before fatal escalation (0 = never)";
            sw = rw;
            hw = r;
        } LIMIT[7:0] = 8'd4;

    } SCHED_TIMEOUT_LIMIT @ 0x208;

    reg {
        name = "Descriptor Engine Configuration";
        desc = "Descriptor engine feature enables (global for all channels)";

        field {
            desc = "Descriptor engine enable - master enable";
            sw = rw;
            hw = r;
        } DESCENG_EN = 1'b1;

        field {
            desc = "Prefetch enable - enable descriptor prefetch";
            sw = rw;
            hw = r;
        } PREFETCH_EN = 1'b0;

        field {
            desc = "FIFO threshold [5:2] - prefetch threshold (4 bits)";
            sw = rw;
            hw = r;
        } FIFO_THRESH[5:2] = 4'h8;

        field {
            desc = "Reserved";
            sw = r;
            hw = na;
        } RSVD[31:6] = 26'h0;

    } DESCENG_CONFIG @ 0x220;

    reg {
        name = "Descriptor Address Range 0 Base";
        desc = "Base address for descriptor address range 0 (lower 32 bits)";

        field {
            desc = "Address range 0 base [31:0]";
            sw = rw;
            hw = r;
        } ADDR0_BASE[31:0] = 32'h0000_0000;

    } DESCENG_ADDR0_BASE @ 0x224;

    reg {
        name = "Descriptor Address Range 0 Limit";
        desc = "Limit address for descriptor address range 0 (lower 32 bits)";

        field {
            desc = "Address range 0 limit [31:0]";
            sw = rw;
            hw = r;
        } ADDR0_LIMIT[31:0] = 32'hFFFF_FFFF;

    } DESCENG_ADDR0_LIMIT @ 0x228;

    reg {
        name = "Descriptor Address Range 1 Base";
        desc = "Base address for descriptor address range 1 (lower 32 bits)";

        field {
            desc = "Address range 1 base [31:0]";
            sw = rw;
            hw = r;
        } ADDR1_BASE[31:0] = 32'h0000_0000;

    } DESCENG_ADDR1_BASE @ 0x22C;

    reg {
        name = "Descriptor Address Range 1 Limit";
        desc = "Limit address for descriptor address range 1 (lower 32 bits)";

        field {
            desc = "Address range 1 limit [31:0]";
            sw = rw;
            hw = r;
        } ADDR1_LIMIT[31:0] = 32'hFFFF_FFFF;

    } DESCENG_ADDR1_LIMIT @ 0x230;

    reg {
        name = "Control Engine Configuration";
        desc = "Control read/write engine configuration (global for all channels,
                Phase 2 producer/consumer). CTRLRD_MAX_TRY bounds ctrl-read poll
                retries so a never-matching gate cannot hang a channel; it feeds
                cfg_ctrlrd_max_try into every channel's ctrlrd_engine.";

        field {
            desc = "Control-read poll retry budget [8:0] (0-511)";
            sw = rw;
            hw = r;
        } CTRLRD_MAX_TRY[8:0] = 9'd16;

        field {
            desc = "Reserved";
            sw = r;
            hw = na;
        } RSVD[31:9] = 23'h0;

    } CTRL_CONFIG @ 0x240;

    reg {
        name = "AXI Transfer Configuration";
        desc = "AXI read and write transfer burst sizes";

        field {
            desc = "AXI read transfer beats [7:0] - ARLEN value (0-255 represents 1-256 beats). The engine clamps it to the per-channel SRAM depth minus one, and to 254 beyond that (rapids BUG-009): a burst is never larger than the buffer that stages it";
            sw = rw;
            hw = r;
        } RD_XFER_BEATS[7:0] = 8'd15;

        field {
            desc = "AXI write transfer beats [15:8] - AWLEN value (0-255 represents 1-256 beats). The engine clamps it to the per-channel SRAM depth minus one, and to 254 beyond that (rapids BUG-009): a burst is never larger than the buffer that stages it";
            sw = rw;
            hw = r;
        } WR_XFER_BEATS[15:8] = 8'd15;

        field {
            desc = "Sink AXIS SRAM allocation size [23:16] - segments reserved per AXIS fill burst";
            sw = rw;
            hw = r;
        } ALLOC_SIZE[23:16] = 8'd16;

        field {
            desc = "Source AXIS drain size [31:24] - beats drained to AXIS per packet request";
            sw = rw;
            hw = r;
        } DRAIN_SIZE[31:24] = 8'd16;

    } AXI_XFER_CONFIG @ 0x2A0;

    reg {
        name = "Performance Profiler Configuration";
        desc = "Performance profiler enable and mode controls";

        field {
            desc = "Performance profiler enable";
            sw = rw;
            hw = r;
        } PERF_EN = 1'b0;

        field {
            desc = "Performance profiler mode - 0=count, 1=histogram";
            sw = rw;
            hw = r;
        } PERF_MODE = 1'b0;

        field {
            desc = "Performance profiler clear - write 1 to clear counters";
            sw = rw;
            hw = r;
            swmod;  // Self-clearing
        } PERF_CLEAR = 1'b0;

        field {
            desc = "Reserved";
            sw = r;
            hw = na;
        } RSVD[31:3] = 29'h0;

    } PERF_CONFIG @ 0x2B0;

    reg {
        name = "Observation Mux Control";
        desc = "Selects which channel and which category drive OBS_FLAGS / OBS_DATA0 / OBS_DATA1";

        field {
            desc = "Channel select (0..NUM_CHANNELS-1)";
            sw = rw;
            hw = r;
        } CH_SEL[2:0] = 3'b0;

        field {
            desc = "Category select: 0=status (data0=sched_rd_beats, data1=sched_wr_beats), 1=rd_addr (data0=lo, data1=hi), 2=wr_addr (data0=lo, data1=hi), 3=sram (data0=rd_space_free, data1=wr_data_avail)";
            sw = rw;
            hw = r;
        } CAT_SEL[4:3] = 2'b0;

        field {
            desc = "Reserved";
            sw = r;
            hw = na;
        } RSVD[31:5] = 27'h0;

    } OBS_CTRL @ 0x2C0;

    reg {
        name = "Observation Flags";
        desc = "Combinational status vector for the channel selected by OBS_CTRL.CH_SEL. See stream_core.sv for the bit layout (scheduler_state, sched_rd/wr_valid, sched_wr_ready, error stickies, idle bits, cfg_channel_enable, axi_*_all_complete).";

        field {
            desc = "Observation flags";
            sw = r;
            hw = w;
        } FLAGS[31:0];

    } OBS_FLAGS @ 0x2C4;

    reg {
        name = "Observation Data 0";
        desc = "Category-muxed data word 0 for the selected channel. Semantics depend on OBS_CTRL.CAT_SEL.";

        field {
            desc = "Observation data 0";
            sw = r;
            hw = w;
        } DATA[31:0];

    } OBS_DATA0 @ 0x2C8;

    reg {
        name = "Observation Data 1";
        desc = "Category-muxed data word 1 for the selected channel. Semantics depend on OBS_CTRL.CAT_SEL.";

        field {
            desc = "Observation data 1";
            sw = r;
            hw = w;
        } DATA[31:0];

    } OBS_DATA1 @ 0x2CC;

    //=========================================================================
    // Tile packet header status (byte RAPIDS, TILE_HDR = 1; TILE_SPEC 11.12).
    // Read zero when TILE_HDR = 0 and in RAPIDS Beats. The W1C fields are LIVE
    // MIRRORS of sticky bits owned by the RTL (sw=rw, hw=w, precedence=sw,
    // woclr, reset 0): the top decodes the write and clears the RTL bit, as
    // the retro_legacy_blocks status registers do. TILE_STATUS is meaningful
    // in the SNK half (the sink port), TILE_DESC_DROPPED in the SRC half.
    //=========================================================================
    reg {
        name = "Tile Header Status";
        desc = "Sink-port tile header status (SNK half). Sticky; write 1 to clear.";

        field {
            desc = "A packet the sink port consumed without acting on it: a read request to RAPIDS, a reserved ptype, a desc packet with no payload, a tag past NUM_CHANNELS or DATA_WIDTH < 256, or extra desc payload. Sticky; write 1 to clear";
            sw = rw; hw = w; precedence = sw; onwrite = woclr;
        } UNSUPPORTED[0:0] = 1'b0;

        field {
            desc = "A data packet whose header tag differed from its stream ID (delivered by stream ID). Sticky; write 1 to clear";
            sw = rw; hw = w; precedence = sw; onwrite = woclr;
        } TAG_MISMATCH[1:1] = 1'b0;

        field {
            desc = "Reserved";
            sw = r;
            hw = na;
        } RSVD[31:2] = 30'h0;

    } TILE_STATUS @ 0x2D0;

    reg {
        name = "Cell Descriptor Drops";
        desc = "Per source channel: a cell-issued descriptor was dropped (SRC half). Sticky; write 1 to clear.";

        field {
            desc = "Channel 0: a cell-issued descriptor was dropped (no free slot, EXT, or during channel reset). Sticky; write 1 to clear";
            sw = rw; hw = w; precedence = sw; onwrite = woclr;
        } DROP0[0:0] = 1'b0;

        field {
            desc = "Channel 1: a cell-issued descriptor was dropped (no free slot, EXT, or during channel reset). Sticky; write 1 to clear";
            sw = rw; hw = w; precedence = sw; onwrite = woclr;
        } DROP1[1:1] = 1'b0;

        field {
            desc = "Channel 2: a cell-issued descriptor was dropped (no free slot, EXT, or during channel reset). Sticky; write 1 to clear";
            sw = rw; hw = w; precedence = sw; onwrite = woclr;
        } DROP2[2:2] = 1'b0;

        field {
            desc = "Channel 3: a cell-issued descriptor was dropped (no free slot, EXT, or during channel reset). Sticky; write 1 to clear";
            sw = rw; hw = w; precedence = sw; onwrite = woclr;
        } DROP3[3:3] = 1'b0;

        field {
            desc = "Channel 4: a cell-issued descriptor was dropped (no free slot, EXT, or during channel reset). Sticky; write 1 to clear";
            sw = rw; hw = w; precedence = sw; onwrite = woclr;
        } DROP4[4:4] = 1'b0;

        field {
            desc = "Channel 5: a cell-issued descriptor was dropped (no free slot, EXT, or during channel reset). Sticky; write 1 to clear";
            sw = rw; hw = w; precedence = sw; onwrite = woclr;
        } DROP5[5:5] = 1'b0;

        field {
            desc = "Channel 6: a cell-issued descriptor was dropped (no free slot, EXT, or during channel reset). Sticky; write 1 to clear";
            sw = rw; hw = w; precedence = sw; onwrite = woclr;
        } DROP6[6:6] = 1'b0;

        field {
            desc = "Channel 7: a cell-issued descriptor was dropped (no free slot, EXT, or during channel reset). Sticky; write 1 to clear";
            sw = rw; hw = w; precedence = sw; onwrite = woclr;
        } DROP7[7:7] = 1'b0;

        field {
            desc = "Reserved";
            sw = r;
            hw = na;
        } RSVD[31:8] = 24'h0;

    } TILE_DESC_DROPPED @ 0x2D4;

    reg {
        name = "Tile Packet Counts";
        desc = "Sink-port packets passed on or consumed (SNK half); 16-bit counters that wrap";

        field {
            desc = "desc packets passed to the source half";
            sw = r;
            hw = w;
        } DESC_COUNT[15:0];

        field {
            desc = "credit packets received (with TILE_CREDITS = 1 they fill the SRC half's destination counters)";
            sw = r;
            hw = w;
        } CREDIT_COUNT[31:16];

    } TILE_COUNTS @ 0x2D8;

    //=========================================================================
    // End-to-end tile credits (byte RAPIDS, TILE_CREDITS = 1; TILE_SPEC 11.9,
    // 11.10). Meaningful in the SRC half, which keeps the 64 destination
    // counters, index {ext, n}: n 0-15 cell-level node {Y[1:0],X[1:0]},
    // 16-19 tetrad node, 20-21 root node, 22-31 spare; ext = 0 the node
    // itself, ext = 1 what is attached to it (32-47 the cells). Read zero
    // when TILE_CREDITS = 0.
    //=========================================================================
    reg {
        name = "Tile Advertisement Window";
        desc = "Cycles from reset during which destinations advertise their credits (SRC half). When the window closes, a destination whose counter is still 0 is illegal (TILE_LEGAL_DEST_LO/HI).";

        field {
            desc = "Window length in cycles from reset. Counted from reset, so a write takes effect only if made before the window closes; 0 closes it at once and makes every destination illegal";
            sw = rw;
            hw = r;
        } CYCLES[31:0] = 32'h0000_1000;

    } TILE_ADV_WINDOW @ 0x2DC;

    reg {
        name = "Tile Legal Destinations, Low";
        desc = "Saved legal-destination mask, indices 0-31: the nodes' internal IDs (SRC half). 1 = the destination advertised a non-zero credit count in the window. Valid once TILE_CREDIT_STATUS.ADV_DONE is 1; held until reset. A descriptor to an illegal destination is refused as invalid.";

        field {
            desc = "Bit i: destination index i is legal";
            sw = r;
            hw = w;
        } LEGAL[31:0];

    } TILE_LEGAL_DEST_LO @ 0x2E0;

    reg {
        name = "Tile Credit Status";
        desc = "End-to-end tile credit status (SRC half)";

        field {
            desc = "The advertisement window has closed and TILE_LEGAL_DEST_LO/HI are valid. Tile descriptors wait until it is 1";
            sw = r;
            hw = w;
        } ADV_DONE[0:0];

        field {
            desc = "A resync (TILE_RESYNC) is waiting for the tile to be quiescent, or its set packets are still going out (rapids TASK-027)";
            sw = r;
            hw = w;
        } RESYNC_BUSY[1:1];

        field {
            desc = "Sticky until reset: a cell sent past its landing-space strap (TILE_LAND_FLITS); the sink port waited for room. A strap contract violation by the sender";
            sw = r;
            hw = w;
        } LAND_OVERRUN[2:2];

        field {
            desc = "Sticky until reset: a control core sent a desc packet past its intake strap (TILE_DESC_PER_CORE); the descriptor was dropped and its entry returned";
            sw = r;
            hw = w;
        } INTAKE_OVERRUN[3:3];

        field {
            desc = "Reserved";
            sw = r;
            hw = na;
        } RSVD[15:4] = 12'h0;

        field {
            desc = "Credit packets RAPIDS has sent to the cells and cores (returns and resync sets); 16-bit, wraps";
            sw = r;
            hw = w;
        } RET_COUNT[31:16];

    } TILE_CREDIT_STATUS @ 0x2E4;

    reg {
        name = "Tile Legal Destinations, High";
        desc = "Saved legal-destination mask, indices 32-63: the external IDs, what is attached to each node (SRC half). Same rules as TILE_LEGAL_DEST_LO.";

        field {
            desc = "Bit i: destination index 32 + i is legal";
            sw = r;
            hw = w;
        } LEGAL[31:0];

    } TILE_LEGAL_DEST_HI @ 0x2E8;

    reg {
        name = "Tile Credit Resync";
        desc = "Restores every legal cell's and control core's strap after a root failover (TILE_SPEC 11.10; SRC half). RAPIDS sends each a set credit packet: a cell its TILE_LAND_FLITS, a core its TILE_DESC_PER_CORE. Taken only while the tile is quiescent (tile_quiescent); a request made before then waits for it.";

        field {
            desc = "Write 1 to request a resync";
            sw = w;
            hw = r;
            singlepulse;
        } GO[0:0] = 1'b0;

        field {
            desc = "Reserved";
            sw = r;
            hw = na;
        } RSVD[31:1] = 31'h0;

    } TILE_RESYNC @ 0x2EC;

    reg {
        name = "Tile Stalled-Data Threshold";
        desc = "Stalled-data checks (TILE_SPEC 11.9; SRC half, used by both): data that has not moved for this many cycles raises a MonBus error packet (PktTypeError, event RAPIDS_EVENT_STALL) -- sink SRAM data not written out, a source channel with reads outstanding and no R beat. The default is 10 us at 100 MHz. TILE_CREDITS = 1 only.";

        field {
            desc = "Threshold in cycles; 0 turns the checks off";
            sw = rw;
            hw = r;
        } CYCLES[31:0] = 32'd1000;

    } TILE_STALL_CYCLES @ 0x2F0;

    reg {
        name = "Tile Stalled Channels";
        desc = "Per channel of this half: its data has stopped moving past TILE_STALL_CYCLES (the current episode; clears when the data moves or drains). TILE_CREDITS = 1 only.";

        field {
            desc = "Bit n: channel n is stalled";
            sw = r;
            hw = w;
        } CH[15:0];

        field {
            desc = "Reserved";
            sw = r;
            hw = na;
        } RSVD[31:16] = 16'h0;

    } TILE_STALLED @ 0x2F4;

    reg {
        name = "Per-Channel Perf Bucket Readout Select";
        desc = "Selects which channel's buckets appear in RD/WRMON_PERF_CH_*";

        field {
            desc = "Channel select (0..NUM_CHANNELS-1)";
            sw = rw;
            hw = r;
        } CH_SEL[2:0] = 3'h0;

        field {
            desc = "Reserved";
            sw = r;
            hw = na;
        } RSVD[31:3] = 29'h0;

    } PERF_CH_SEL @ 0x35C;

    reg {
        name = "Latency Histogram Readout Select";
        desc = "Selects bus/metric/bin presented in HIST_DATA / HIST_TOTAL";

        field {
            desc = "Bus: 0=data-read R bus, 1=data-write W bus";
            sw = rw;
            hw = r;
        } BUS = 1'b0;

        field {
            desc = "Metric: 0=AR->firstR (rd) / AW->B (wr), 1=AR->RLAST (rd only)";
            sw = rw;
            hw = r;
        } METRIC = 1'b0;

        field {
            desc = "Latency bin index (0..15, log2)";
            sw = rw;
            hw = r;
        } BIN[5:2] = 4'h0;

        field {
            desc = "Reserved";
            sw = r;
            hw = na;
        } RSVD[31:6] = 26'h0;

    } HIST_SEL @ 0x378;

    reg {
        name = "Latency Histogram Bin Count";
        desc = "Transaction count in the HIST_SEL-selected bus/metric/bin";

        field {
            desc = "Selected histogram bin count [31:0]";
            sw = r;
            hw = w;
        } VAL[31:0];

    } HIST_DATA @ 0x37C;

    reg {
        name = "Latency Histogram Metric Total";
        desc = "Total transactions for the HIST_SEL-selected bus/metric (= sum
                over all bins). Equals the burst/transaction count, an
                acceptance cross-check against the perf-window burst counters.";

        field {
            desc = "Selected metric total transaction count [31:0]";
            sw = r;
            hw = w;
        } VAL[31:0];

    } HIST_TOTAL @ 0x380;

    // The last word of the config space, below the monitor block: fixed so
    // the Hive finds it without knowing the rest of the map.
    reg {
        name = "Tile Straps";
        desc = "The straps this RAPIDS reserves toward it (TILE_SPEC 11.9), from
                its build parameters, for the Hive to check against the cells'
                and cores' straps. Both fields read 0 when TILE_CREDITS = 0 (no
                straps). The same values in both halves.";

        field {
            desc = "TILE_LAND_FLITS: landing-space flits per cell, header included";
            sw = r;
            hw = w;
        } LAND_FLITS[15:0];

        field {
            desc = "TILE_DESC_PER_CORE: descriptor-intake entries per control core";
            sw = r;
            hw = w;
        } DESC_PER_CORE[31:16];

    } TILE_STRAPS @ 0x7FC;

    //=========================================================================
    // AXI Monitor register block - within this engine instance at +0x800 (fits in 4KB).
    // Hookup chosen by a parameter at integration (USE_MON_REGS / USE_AXI_MONITORS);
    // when strapped off the monitor config outputs are tied off in the config block.
    //=========================================================================
    rapids_mon_regs MON @ 0x800;

};
