// SPDX-License-Identifier: MIT
// SPDX-FileCopyrightText: 2026 sean galloway
//
// DDR2/LPDDR2 characterization TRAFFIC-GENERATOR configuration — PeakRDL source
//
// UNLIKE harness_csr.rdl, THIS ONE GENERATES ITS RTL. harness_csr.sv is hand
// written because it carries self-clearing pulses, latches and the a7ddrphy
// indirect window that PeakRDL cannot express; the generator config is plain
// staged state plus one launch pulse, so there is no reason to hand-write 176
// registers. Regenerate with bin/peakrdl_generate.py (never `peakrdl regblock`
// directly — the wrapper emits RTL, docs and the Python regmap in lockstep):
//
//   cd $REPO_ROOT && source env_python
//   python3 bin/peakrdl_generate.py \
//       projects/fpga-systems/rtl/mem_char_framework/rtl/chargen_regs.rdl \
//       -o projects/fpga-systems/rtl/mem_char_framework/rtl/generated/chargen_regs \
//       --regmap-output projects/fpga-systems/rtl/mem_char_framework/dv/tbclasses/chargen_regs_regmap.py
//
//=============================================================================
// WHY THIS IS A SEPARATE BLOCK FROM harness_csr
//=============================================================================
// The harness owns harness_csr and always will: build identity, the DFI tuning
// tuple, the timer, the trace ring, the PHY window. Those describe THE BOARD.
//
// The generators describe THE WORKLOAD, and there are now sixteen of them —
// eight writers and eight readers, one per DRAM bank. Folding sixteen copies of
// an eleven-register config into harness_csr would triple that file's register
// count with state the harness itself never reads, and would put a
// hand-maintained map in front of a surface that is pure array. So the
// generators get their own regblock behind their own APB slave, and the harness
// is reduced to instantiation — the same argument obs_regs made for the
// observer, and it applies here for the same reason.
//
//=============================================================================
// WHY EIGHT OF EACH
//=============================================================================
// One generator per bank. The flat ~12.7 MB/s board result was traced to the
// arbiter falling back to a single oldest bank (serialised ACT -> tRCD ->
// access) — but a harness that drives ONE address stream cannot tell that apart
// from a controller that refuses to go bank-parallel. Eight independently
// addressed generators make bank concurrency a property of the stimulus rather
// than of a hand-built address pattern, so the measurement can distinguish the
// two. NUM_GEN is fixed at 8 to match NUM_BANKS on the MT47H64M16; the harness
// asserts the two agree rather than trusting them to.
//
// Splitting read from write is the other half of the same argument: with the
// directions on separate bridges the mix is a knob, so read/write turnaround
// (tWTR/tRTW) can be swept instead of being an accidental constant in every
// number.
//
//=============================================================================
// LAUNCH IS GLOBAL, ON PURPOSE
//=============================================================================
// Every generator is STAGED first (write its config, in any order, over as many
// bus transactions as it takes), then all sixteen start on one cycle from a
// single write to GO. Staging and launching are separate because a per-
// generator start bit means the first generator has been running for however
// many microseconds it took the host to program the last one — on the rapids
// characterization that skew was enough to produce 0%-utilization windows and a
// meaningless number. One write, one start edge, one measurement window.
//
// Address space: 4 KB APB window (12-bit PADDR), matching the bridge slot.
//   0x000..0x1FF   WR_GEN[0..7]   0x40 stride
//   0x200..0x5FF   RD_GEN[0..7]   0x80 stride
//   0x600..        global launch / status / identity
// Eight per direction since 2026-10-22 (owner: "each of the injectors should
// be able to run 8 threads at once"); the arrays were four and the global
// block sat at 0x400. Hosts address every register BY NAME through the
// generated regmap, so the move costs nothing there; a host that hard-coded
// 0x400 for GO is the thing this comment is for.
//=============================================================================

addrmap chargen_regs {
    name = "DDR2 characterization traffic-generator configuration";
    desc = "Per-bank AXI4 write/read pattern-generator config, staged then launched together";

    default regwidth    = 32;
    default accesswidth = 32;
    default alignment   = 4;

    //=========================================================================
    // Shared config register types
    //
    // Field widths are the ENGINE's widths, not 32 rounded up. STRIDE_WIDTH is
    // 24 and TXN_COUNT_WIDTH is 16 on both engines; declaring them at their
    // true width makes an over-wide host write read back as what the hardware
    // will actually use, instead of silently dropping the top bits somewhere
    // downstream. That distinction is not academic here — a truncation nobody
    // could see is how the BL4/BL8 geometry mismatch survived six weeks.
    //=========================================================================
    // NOTE ON FIELD NAMES: none of these is called `value`. PeakRDL emits the
    // field as a struct member under the register, so a field named `value`
    // produces `START_ADDR.value.value` -- two identifiers of the same name at
    // adjacent nesting levels, which the repo's declaration-order gate
    // (bin/check_sv_decl_order.py) reports as a use-before-declaration. It is a
    // false positive, but every other generated regblock here (obs_regs,
    // pumice_csr) already avoids the name, so this one does too rather than
    // teach the checker about a shape only this file has. Descriptive names are
    // better anyway: `.addr` says what it is and `.value` does not.
    reg addr_t {  desc = "32-bit address";
        field { sw = rw; hw = r; } addr[31:0]  = 0; };
    reg mask_t {  desc = "32-bit address wrap mask";
        field { sw = rw; hw = r; } mask[31:0]  = 0; };
    reg seed_t {  desc = "32-bit generator seed";
        field { sw = rw; hw = r; } seed[31:0]  = 0; };
    reg fill_t {  desc = "32-bit fill pattern, replicated across the data bus in data_mode=2";
        field { sw = rw; hw = r; } pattern[31:0] = 0; };
    reg crc_t {   desc = "32-bit CRC, computed by the engine";
        field { sw = r;  hw = w; } crc[31:0]   = 0; };
    reg count_t { desc = "32-bit event count, computed by the engine";
        // NOT `count`: TBClasses/apb/register_map.py reserves that key for a
        // register array's element count, so a field of that name makes
        // RegisterMap read a dict where it expects an int and the whole map
        // fails to construct. Same class of collision as `value` above, found
        // the same way -- by loading the generated regmap before trusting it.
        field { sw = r;  hw = w; } beats[31:0] = 0; };

    reg stride_t {
        desc = "Signed address stride, STRIDE_WIDTH=24 (two's complement)";
        field { sw = rw; hw = r; } stride[23:0] = 0;
    };

    reg blen_txn_t {
        desc = "Burst length / transaction count / inter-burst gap";
        // burst_len is in BEATS (1..256); the engine emits AxLEN = burst_len-1.
        // It must stay a whole DRAM burst: a half burst is ILLEGAL in the
        // generators, not merely slow, and the harness checks it.
        field { sw = rw; hw = r; } burst_len[7:0]   = 0;
        field { sw = rw; hw = r; } txn_count[23:8]  = 0;
        field { sw = rw; hw = r; } gap[27:24]       = 0;
        // Both directions (readers since 2026-10-25; before that write
        // generators only): the idle gap between bursts is gap << gap_shift
        // cycles (0..15 x 1..128). 0 -- the reset value -- keeps the original
        // 0..15. A 4-bit gap cannot throttle a generator below what a slow
        // memory absorbs (the Genesys 2 fabric benchmark's W3 mix needs ~960
        // idle cycles between 16-beat bursts).
        field { sw = rw; hw = r; } gap_shift[30:28] = 0;
    };

    reg axi_attr_t {
        desc = "AXI id / id_mode / size / burst / hammer_en / data_mode / outstanding cap";
        field { sw = rw; hw = r; } axi_id[7:0]      = 0;
        field { sw = rw; hw = r; } id_mode[9:8]     = 0;
        field { sw = rw; hw = r; } axi_size[12:10]  = 0;
        field { sw = rw; hw = r; } axi_burst[14:13] = 0;
        // Data source: 0 = LFSR phase counter, 1 = address-derived hash,
        // 2 = FILL_PATTERN replicated across the data bus. Widened from one
        // bit at [15] to two bits at [16:15] so everything below bit 15 is
        // unchanged; bit 14 is already occupied by axi_burst.
        field { sw = rw; hw = r; } data_mode[16:15] = 0;
        // Rowhammer / aggressor-pair mode: the address-generator index becomes
        // the LSB of the transaction counter, so addresses alternate
        // base / base+stride_0 per transaction. stride_0 is reused as the
        // aggressor-pair offset.
        field { sw = rw; hw = r; } hammer_en[17:17] = 0;
        // Active cap on bursts in flight for THIS generator, 1..GEN_MAX_
        // OUTSTANDING. 0 = as built, which is also the reset value, so a host
        // that never writes this field gets the pre-existing behaviour.
        //
        // This is the sweep axis for bandwidth against outstanding
        // transactions: one bitstream is built at the ceiling and the host
        // walks the limit down, instead of one bitstream per point. Writes
        // above the built ceiling saturate at it in RTL rather than wrapping.
        // Six bits, so a 32-deep build is reachable and 33..63 still clamp
        // visibly instead of aliasing to a small number.
        field { sw = rw; hw = r; } max_outstanding[23:18] = 0;
        // Address index shaping (TASK-049). idx1_shift = k feeds the low k
        // bits of the transaction index to dma_address_gen's dimension 0 and
        // the rest to dimension 1 (0 = the legacy one-dimensional walk, the
        // reset). addr_lfsr = 1 replaces the transaction counter with a
        // maximal 16-bit LFSR seeded from LFSR_SEED, so the walk is
        // pseudo-random inside the wrap region; writer and reader with the
        // same seed produce the same address sequence. Repeated addresses
        // validate only with the address-hash data mode.
        field { sw = rw; hw = r; } idx1_shift[27:24]     = 0;
        field { sw = rw; hw = r; } addr_lfsr[28:28]      = 0;
        // pumice TASK-060. idx1_bit = 1 makes dimension 1 the SINGLE bit
        // idx1_shift of the transaction index and dimension 0 the index with
        // that bit removed: stride_1 toggles every 2^k transactions while
        // stride_0 keeps walking (stride_0 = a DRAM burst, stride_1 = half a
        // burst, k = 3: the low halves of eight bursts, then their high
        // halves, then the next eight). gap_sweep = 1 makes the idle gap
        // after burst n gap + (n mod 8), saturating, so the inter-burst
        // delay walks 0..7 above the base and repeats. Both directions.
        field { sw = rw; hw = r; } idx1_bit[29:29]       = 0;
        field { sw = rw; hw = r; } gap_sweep[30:30]      = 0;
    };

    //=========================================================================
    // One write generator (axi4_master_wr_injector)
    //
    // Config occupies 0x00..0x28 in exactly the order and layout harness_csr
    // used for the single-engine build, so host code that programmed the old
    // WR_* block ports across unchanged — only the base address moves.
    //=========================================================================
    regfile wr_gen_t {
        addr_t     START_ADDR   @ 0x00;
        stride_t   STRIDE_0     @ 0x04;
        stride_t   STRIDE_1     @ 0x08;
        mask_t     WRAP_MASK_0  @ 0x0C;
        mask_t     WRAP_MASK_1  @ 0x10;
        blen_txn_t BLEN_TXN     @ 0x14;
        axi_attr_t AXI_ATTR     @ 0x18;
        seed_t     LFSR_SEED    @ 0x1C;
        seed_t     HASH_SEED0   @ 0x20;
        seed_t     HASH_SEED1   @ 0x24;
        seed_t     HASH_SEED2   @ 0x28;
        fill_t     FILL_PATTERN @ 0x2C;

        reg {
            desc = "Per-generator completion and sticky error status";
            field { sw = r; hw = w; } done[0:0]        = 0;  // all B responses received
            field { sw = r; hw = w; } crc_valid[1:1]   = 0;  // asserted with done
            field { sw = r; hw = w; } bresp_error[2:2] = 0;  // sticky, any non-OKAY BRESP
        } STATUS @ 0x30;

        // The pattern this generator wrote, as the writer computed it. The
        // reader on the same bank recomputes it independently; the host
        // compares. Neither side is told the answer.
        crc_t      EXPECTED_CRC @ 0x34;
    };

    //=========================================================================
    // One read generator (axi4_master_rd_crc_check)
    //
    // Same config layout as the writer -- deliberately, so a host can program
    // a matched pair from one routine -- with a wider status because the reader
    // is the checking side.
    //=========================================================================
    regfile rd_gen_t {
        addr_t     START_ADDR   @ 0x00;
        stride_t   STRIDE_0     @ 0x04;
        stride_t   STRIDE_1     @ 0x08;
        mask_t     WRAP_MASK_0  @ 0x0C;
        mask_t     WRAP_MASK_1  @ 0x10;
        blen_txn_t BLEN_TXN     @ 0x14;
        axi_attr_t AXI_ATTR     @ 0x18;
        seed_t     LFSR_SEED    @ 0x1C;
        seed_t     HASH_SEED0   @ 0x20;
        seed_t     HASH_SEED1   @ 0x24;
        seed_t     HASH_SEED2   @ 0x28;
        fill_t     FILL_PATTERN @ 0x2C;

        reg {
            desc = "Per-generator completion and sticky error status";
            field { sw = r; hw = w; } done[0:0]              = 0;
            field { sw = r; hw = w; } crc_valid[1:1]         = 0;
            field { sw = r; hw = w; } data_error[2:2]        = 0;  // sticky, R beat mismatch
            field { sw = r; hw = w; } rresp_error[3:3]       = 0;  // sticky, non-OKAY R beat
            field { sw = r; hw = w; } stray_beat_error[4:4]  = 0;  // sticky, beat with no outstanding AR
        } STATUS @ 0x30;

        crc_t      ACTUAL_CRC   @ 0x34;

        // Counts, not just flags. "Some beats were wrong" and "one beat in
        // three thousand was wrong" call for different investigations, and the
        // sticky bit cannot tell them apart.
        count_t    BEATS_MISM   @ 0x38;
        count_t    STRAY_BEATS  @ 0x3C;

        // Accumulated popcount of mismatched bits across the run, saturated at
        // all-ones. Quantifies rowhammer-induced bit flips without disturbing
        // the beat-level mismatch count.
        count_t    ERR_BITS     @ 0x40;
    };

    //=========================================================================
    // The arrays. Index == DRAM bank, by convention the host is expected to
    // honour -- nothing in hardware forces generator N onto bank N, because
    // the bank field's position is pumice's ADDR_MAP.bank_lsb and therefore
    // runtime state. The host computes each START_ADDR from the map it
    // programmed. Getting this wrong does not fail; it silently measures
    // something other than bank concurrency, so the host asserts the mapping.
    //=========================================================================
    wr_gen_t WR_GEN[8] @ 0x000 += 0x40;
    rd_gen_t RD_GEN[8] @ 0x200 += 0x80;

    //=========================================================================
    // Global launch and roll-up (0x600..)
    //=========================================================================
    reg {
        desc = "Launch. Writing a 1 starts that generator; bits are self-clearing, so one write starts any subset on a single cycle.";
        // singlepulse is defined per FIELD and a field must be one bit wide, so
        // the mask is written out bit by bit. It is still one register and one
        // write: every bit set in that write pulses on the same cycle.
        field { sw = w; hw = r; singlepulse; } wr_go0[0:0] = 0;
        field { sw = w; hw = r; singlepulse; } wr_go1[1:1] = 0;
        field { sw = w; hw = r; singlepulse; } wr_go2[2:2] = 0;
        field { sw = w; hw = r; singlepulse; } wr_go3[3:3] = 0;
        field { sw = w; hw = r; singlepulse; } wr_go4[4:4] = 0;
        field { sw = w; hw = r; singlepulse; } wr_go5[5:5] = 0;
        field { sw = w; hw = r; singlepulse; } wr_go6[6:6] = 0;
        field { sw = w; hw = r; singlepulse; } wr_go7[7:7] = 0;
        field { sw = w; hw = r; singlepulse; } rd_go0[8:8] = 0;
        field { sw = w; hw = r; singlepulse; } rd_go1[9:9] = 0;
        field { sw = w; hw = r; singlepulse; } rd_go2[10:10] = 0;
        field { sw = w; hw = r; singlepulse; } rd_go3[11:11] = 0;
        field { sw = w; hw = r; singlepulse; } rd_go4[12:12] = 0;
        field { sw = w; hw = r; singlepulse; } rd_go5[13:13] = 0;
        field { sw = w; hw = r; singlepulse; } rd_go6[14:14] = 0;
        field { sw = w; hw = r; singlepulse; } rd_go7[15:15] = 0;
    } GO @ 0x600;

    reg {
        desc = "Per-generator done, gathered so a poll costs one read instead of sixteen";
        field { sw = r; hw = w; } wr_done[7:0]  = 0;
        field { sw = r; hw = w; } rd_done[15:8] = 0;
    } DONE @ 0x604;

    reg {
        desc = "Sticky error roll-up across all generators; read STATUS per generator to localise";
        field { sw = r; hw = w; } wr_bresp_error[7:0] = 0;
        field { sw = r; hw = w; } rd_any_error[15:8]  = 0;
    } ERRORS @ 0x608;

    //=========================================================================
    // Identity. Driven from the harness's own parameters so the count the host
    // programs cannot drift from the count that was compiled -- the same
    // argument BUILD_CONFIG makes in harness_csr, and made for the same reason:
    // a geometry assumption that is wrong shows up as garbage data, not as a
    // mismatch anyone can see.
    //=========================================================================
    reg {
        desc = "Compile-time generator array shape";
        field { sw = r; hw = w; } num_wr_gen[7:0]  = 8;
        field { sw = r; hw = w; } num_rd_gen[15:8] = 8;
        field { sw = r; hw = w; } num_banks[23:16] = 8;
    } GEN_CONFIG @ 0x610;

    reg { desc = "Block identity (ASCII CGEN)";
        field { sw = r; hw = w; } id[31:0] = 0x4347454E; } BLOCK_ID @ 0x614;

    //=========================================================================
    // Refresh alignment (memory-controllers MC-025). The controller's tREFI
    // countdown free-runs from init, so a run's GO lands at an arbitrary
    // refresh phase and a pass-to-pass A/B carries that draw (ISSUE-005 /
    // ISSUE-007). Armed, every launch (any GO bit) reloads the controller's
    // countdown `offset` cycles later, so refresh sits at the same cycle
    // relative to the first transaction on every run, and `offset` sweeps the
    // phase on purpose. Off by default; a controller that does not take the
    // pulse (only granite does) ignores it.
    //=========================================================================
    reg {
        desc = "Refresh alignment: reload the controller's tREFI countdown OFFSET mc_clk cycles after each launch";
        field { sw = rw; hw = r; desc = "1 = pulse the reload on every launch"; } en[0:0] = 0;
        field { sw = rw; hw = r; desc = "cycles from launch to the reload"; } offset[31:16] = 0;
    } REF_ALIGN @ 0x618;
};
